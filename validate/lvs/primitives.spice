* Pin-named definitions of the cells that the chipalooza_frame schematic
* instantiates as xschem PRIMITIVES and that have no other netlist to read.
* A primitive binds POSITIONALLY, so the pin order here is the symbol's,
* and the names are those used on the structural (Verilog) side.
* Read into circuit 2 before the schematic;  see the Makefile.

* SPI and clock pad loopbacks.  The names are made up here and in
* gen_blackboxes.py;  setup.tcl permutes them, as a resistor is symmetric.
.subckt rm2 PLUS MINUS
.ends

* Mask revision block, from verilog/gl/user_id_programming.v
.subckt user_id_programming VDD VSS
+ mask_rev[31] mask_rev[30] mask_rev[29] mask_rev[28] mask_rev[27] mask_rev[26] mask_rev[25] mask_rev[24]
+ mask_rev[23] mask_rev[22] mask_rev[21] mask_rev[20] mask_rev[19] mask_rev[18] mask_rev[17] mask_rev[16]
+ mask_rev[15] mask_rev[14] mask_rev[13] mask_rev[12] mask_rev[11] mask_rev[10] mask_rev[9] mask_rev[8]
+ mask_rev[7] mask_rev[6] mask_rev[5] mask_rev[4] mask_rev[3] mask_rev[2] mask_rev[1] mask_rev[0]
.ends
