** sch_path: /home/tim/gits/gf180mcu_ocd_chipalooza/xschem/gf180mcu_ocd_chipalooza.sch
.subckt gf180mcu_ocd_chipalooza SDO analog[3] analog[2] analog[1] analog[0] gpio[11] gpio[10] gpio[9] gpio[8] gpio[7] gpio[6]
+ gpio[5] gpio[4] gpio[3] gpio[2] gpio[1] gpio[0] vdd5v0 vss5v0 vdd3v3 vss3v3 vddd SDI SCK clk CSB s18_an[1] s18_an[0] s17_an[1] s17_an[0]
+ s16_an[1] s16_an[0] s15_an[1] s15_an[0] s14_an[1] s14_an[0] s13_an[1] s13_an[0] s12_an[1] s12_an[0] s11_an[0] s10_an[2] s10_an[1] s10_an[0]
+ s9_an[2] s9_an[1] s9_an[0] s8_an[0] s7_an[1] s7_an[0] s6_an[1] s6_an[0] s5_an[1] s5_an[0] s4_an[1] s4_an[0] s3_an[1] s3_an[0] s2_an[1]
+ s2_an[0] s1_an[1] s1_an[0]
*.PININFO SDO:B analog[3:0]:B gpio[11:0]:B vdd5v0:B vss5v0:B vdd3v3:B vss3v3:B vddd:B SDI:I SCK:I clk:I CSB:I s18_an[1:0]:B
*+ s17_an[1:0]:B s16_an[1:0]:B s15_an[1:0]:B s14_an[1:0]:B s13_an[1:0]:B s12_an[1:0]:B s11_an[0]:B s10_an[2:0]:B s9_an[2:0]:B s8_an[0]:B
*+ s7_an[1:0]:B s6_an[1:0]:B s5_an[1:0]:B s4_an[1:0]:B s3_an[1:0]:B s2_an[1:0]:B s1_an[1:0]:B
x1 vdd3v3 vss3v3 vdd5v0 vss5v0 vddd gpio[11] gpio[10] gpio[9] gpio[8] gpio[7] gpio[6] gpio[5] gpio[4] gpio[3] gpio[2] gpio[1]
+ gpio[0] analog[3] analog[2] analog[1] analog[0] SDO SDI CSB SCK clk s1_an[1] s1_an[0] s2_an[1] s2_an[0] s3_an[1] s3_an[0] s4_an[1]
+ s4_an[0] s5_an[1] s5_an[0] s6_an[1] s6_an[0] s7_an[1] s7_an[0] s8_an[0] s9_an[2] s9_an[1] s9_an[0] s10_an[2] s10_an[1] s10_an[0] s11_an[0]
+ s12_an[1] s12_an[0] s13_an[1] s13_an[0] s14_an[1] s14_an[0] s15_an[1] s15_an[0] s16_an[1] s16_an[0] s17_an[1] s17_an[0] s18_an[1] s18_an[0]
+ gpio_in[11] gpio_in[10] gpio_in[9] gpio_in[8] gpio_in[7] gpio_in[6] gpio_in[5] gpio_in[4] gpio_in[3] gpio_in[2] gpio_in[1] gpio_in[0]
+ net4[11] net4[10] net4[9] net4[8] net4[7] net4[6] net4[5] net4[4] net4[3] net4[2] net4[1] net4[0] net3[11] net3[10] net3[9] net3[8]
+ net3[7] net3[6] net3[5] net3[4] net3[3] net3[2] net3[1] net3[0] gpio_out[11] gpio_out[10] gpio_out[9] gpio_out[8] gpio_out[7] gpio_out[6]
+ gpio_out[5] gpio_out[4] gpio_out[3] gpio_out[2] gpio_out[1] gpio_out[0] gpio_oe[11] gpio_oe[10] gpio_oe[9] gpio_oe[8] gpio_oe[7] gpio_oe[6]
+ gpio_oe[5] gpio_oe[4] gpio_oe[3] gpio_oe[2] gpio_oe[1] gpio_oe[0] gpio_ie[11] gpio_ie[10] gpio_ie[9] gpio_ie[8] gpio_ie[7] gpio_ie[6]
+ gpio_ie[5] gpio_ie[4] gpio_ie[3] gpio_ie[2] gpio_ie[1] gpio_ie[0] gpio_slew[11] gpio_slew[10] gpio_slew[9] gpio_slew[8] gpio_slew[7]
+ gpio_slew[6] gpio_slew[5] gpio_slew[4] gpio_slew[3] gpio_slew[2] gpio_slew[1] gpio_slew[0] gpio_schmitt[11] gpio_schmitt[10] gpio_schmitt[9]
+ gpio_schmitt[8] gpio_schmitt[7] gpio_schmitt[6] gpio_schmitt[5] gpio_schmitt[4] gpio_schmitt[3] gpio_schmitt[2] gpio_schmitt[1] gpio_schmitt[0]
+ gpio_pullup[11] gpio_pullup[10] gpio_pullup[9] gpio_pullup[8] gpio_pullup[7] gpio_pullup[6] gpio_pullup[5] gpio_pullup[4] gpio_pullup[3]
+ gpio_pullup[2] gpio_pullup[1] gpio_pullup[0] gpio_pulldown[11] gpio_pulldown[10] gpio_pulldown[9] gpio_pulldown[8] gpio_pulldown[7]
+ gpio_pulldown[6] gpio_pulldown[5] gpio_pulldown[4] gpio_pulldown[3] gpio_pulldown[2] gpio_pulldown[1] gpio_pulldown[0] net2 SDO_zero net1 sdo_out
+ sdo_ena SDO_ie SDO_slew SDO_schmitt SDO_pullup SDO_pulldown SDI_in SDI_zero net5 SDI_pullup SDI_pulldown CSB_in CSB_zero CSB_one
+ CSB_pullup CSB_pulldown SCK_in SCK_zero net6 SCK_pullup SCK_pulldown clk_in clk_zero net7 clk_pullup clk_pulldown gf180mcu_padframe
x2 SDO_ie SDO_schmitt SDO_slew SDO_pullup SDO_pulldown SDO_zero clk_pullup clk_zero clk_pulldown SDI_pullup SDI_pulldown SDI_zero
+ SCK_pullup SCK_zero SCK_pulldown vdd5v0 vss5v0 CSB_pullup CSB_zero vdd3v3 CSB_pulldown CSB_one vss3v3 vddd gpio_out[11] gpio_out[10]
+ gpio_out[9] gpio_out[8] gpio_out[7] gpio_out[6] gpio_out[5] gpio_out[4] gpio_out[3] gpio_out[2] gpio_out[1] gpio_out[0] gpio_oe[11]
+ gpio_oe[10] gpio_oe[9] gpio_oe[8] gpio_oe[7] gpio_oe[6] gpio_oe[5] gpio_oe[4] gpio_oe[3] gpio_oe[2] gpio_oe[1] gpio_oe[0] gpio_in[11]
+ gpio_in[10] gpio_in[9] gpio_in[8] gpio_in[7] gpio_in[6] gpio_in[5] gpio_in[4] gpio_in[3] gpio_in[2] gpio_in[1] gpio_in[0] gpio_ie[11]
+ gpio_ie[10] gpio_ie[9] gpio_ie[8] gpio_ie[7] gpio_ie[6] gpio_ie[5] gpio_ie[4] gpio_ie[3] gpio_ie[2] gpio_ie[1] gpio_ie[0] gpio_schmitt[11]
+ gpio_schmitt[10] gpio_schmitt[9] gpio_schmitt[8] gpio_schmitt[7] gpio_schmitt[6] gpio_schmitt[5] gpio_schmitt[4] gpio_schmitt[3] gpio_schmitt[2]
+ gpio_schmitt[1] gpio_schmitt[0] gpio_slew[11] gpio_slew[10] gpio_slew[9] gpio_slew[8] gpio_slew[7] gpio_slew[6] gpio_slew[5] gpio_slew[4]
+ gpio_slew[3] gpio_slew[2] gpio_slew[1] gpio_slew[0] gpio_pullup[11] gpio_pullup[10] gpio_pullup[9] gpio_pullup[8] gpio_pullup[7]
+ gpio_pullup[6] gpio_pullup[5] gpio_pullup[4] gpio_pullup[3] gpio_pullup[2] gpio_pullup[1] gpio_pullup[0] gpio_pulldown[11] gpio_pulldown[10]
+ gpio_pulldown[9] gpio_pulldown[8] gpio_pulldown[7] gpio_pulldown[6] gpio_pulldown[5] gpio_pulldown[4] gpio_pulldown[3] gpio_pulldown[2]
+ gpio_pulldown[1] gpio_pulldown[0] analog[3] analog[2] analog[1] analog[0] CSB_in SDI_in SCK_in sdo_ena clk_in sdo_out s9_an[0] s9_an[1] s9_an[2]
+ s10_an[0] s10_an[1] s10_an[2] vss3v3 vss5v0 s8_an[0] s11_an[0] s7_an[0] s7_an[1] s12_an[0] s12_an[1] s6_an[0] s6_an[1] s13_an[0] s13_an[1]
+ s5_an[0] s5_an[1] s14_an[0] s14_an[1] s4_an[0] s4_an[1] s15_an[0] s15_an[0] s3_an[0] s3_an[1] s16_an[0] s16_an[1] vss3v3 vss5v0 s2_an[0]
+ s2_an[1] s17_an[0] s17_an[1] s1_an[0] s1_an[1] s18_an[0] s18_an[1] vss5v0 vss5v0 vss3v3 vss3v3 chipalooza_frame
* noconn #net4
* noconn #net3
* noconn #net7
* noconn #net6
* noconn #net5
* noconn #net1
* noconn #net2
.ends

* expanding   symbol:  chipalooza_frame.sym # of pins=65
** sym_path: /home/tim/gits/gf180mcu_ocd_chipalooza/xschem/chipalooza_frame.sym
** sch_path: /home/tim/gits/gf180mcu_ocd_chipalooza/xschem/chipalooza_frame.sch
.subckt chipalooza_frame SDO_ie SDO_schmitt SDO_slew SDO_pullup SDO_pulldown SDO_zero clk_pullup clk_zero clk_pulldown SDI_pullup
+ SDI_pulldown SDI_zero SCK_pullup SCK_zero SCK_pulldown vdd5v0 vss5v0 CSB_pulldown CSB_zero vdd3v3 CSB_pullup CSB_one vss3v3 vddd gpio_out[11]
+ gpio_out[10] gpio_out[9] gpio_out[8] gpio_out[7] gpio_out[6] gpio_out[5] gpio_out[4] gpio_out[3] gpio_out[2] gpio_out[1] gpio_out[0]
+ gpio_oe[11] gpio_oe[10] gpio_oe[9] gpio_oe[8] gpio_oe[7] gpio_oe[6] gpio_oe[5] gpio_oe[4] gpio_oe[3] gpio_oe[2] gpio_oe[1] gpio_oe[0]
+ gpio_in[11] gpio_in[10] gpio_in[9] gpio_in[8] gpio_in[7] gpio_in[6] gpio_in[5] gpio_in[4] gpio_in[3] gpio_in[2] gpio_in[1] gpio_in[0]
+ gpio_ie[11] gpio_ie[10] gpio_ie[9] gpio_ie[8] gpio_ie[7] gpio_ie[6] gpio_ie[5] gpio_ie[4] gpio_ie[3] gpio_ie[2] gpio_ie[1] gpio_ie[0]
+ gpio_schmitt[11] gpio_schmitt[10] gpio_schmitt[9] gpio_schmitt[8] gpio_schmitt[7] gpio_schmitt[6] gpio_schmitt[5] gpio_schmitt[4] gpio_schmitt[3]
+ gpio_schmitt[2] gpio_schmitt[1] gpio_schmitt[0] gpio_slew[11] gpio_slew[10] gpio_slew[9] gpio_slew[8] gpio_slew[7] gpio_slew[6] gpio_slew[5]
+ gpio_slew[4] gpio_slew[3] gpio_slew[2] gpio_slew[1] gpio_slew[0] gpio_pullup[11] gpio_pullup[10] gpio_pullup[9] gpio_pullup[8] gpio_pullup[7]
+ gpio_pullup[6] gpio_pullup[5] gpio_pullup[4] gpio_pullup[3] gpio_pullup[2] gpio_pullup[1] gpio_pullup[0] gpio_pulldown[11] gpio_pulldown[10]
+ gpio_pulldown[9] gpio_pulldown[8] gpio_pulldown[7] gpio_pulldown[6] gpio_pulldown[5] gpio_pulldown[4] gpio_pulldown[3] gpio_pulldown[2]
+ gpio_pulldown[1] gpio_pulldown[0] analog[3] analog[2] analog[1] analog[0] CSB_in SDI_in SCK_in SDO_ena clk_in SDO_out s9_an[0] s9_an[1] s9_an[2]
+ s10_an[0] s10_an[1] s10_an[2] vss3v3_slot11 vss5v0_slot8 s8_an[0] s11_an[0] s7_an[0] s7_an[1] s12_an[0] s12_an[1] s6_an[0] s6_an[1]
+ s13_an[0] s13_an[1] s5_an[0] s5_an[1] s14_an[0] s14_an[1] s4_an[0] s4_an[1] s15_an[0] s15_an[1] s3_an[0] s3_an[1] s16_an[0] s16_an[1]
+ vss3v3_slot17 vss5v0_slot2 s2_an[0] s2_an[1] s17_an[0] s17_an[1] s1_an[0] s1_an[1] s18_an[0] s18_an[1] vss5v0_slot12_13 vss5v0_slot14_15
+ vss3v3_slot4_5 vss3v3_slot6_7
*.PININFO vdd5v0:B vdd3v3:B vss3v3:B clk_in:I SDO_out:O SDO_ena:O SDI_in:I CSB_in:I SCK_in:I gpio_in[11:0]:I gpio_out[11:0]:O
*+ gpio_oe[11:0]:O analog[3:0]:O s10_an[0:2]:B s11_an[0]:B s12_an[0:1]:B s13_an[0:1]:B s14_an[0:1]:B s15_an[0:1]:B s16_an[0:1]:B s17_an[0:1]:B
*+ s18_an[0:1]:B s1_an[0:1]:B s2_an[0:1]:B s3_an[0:1]:B s4_an[0:1]:B s5_an[0:1]:B s6_an[0:1]:B s7_an[0:1]:B s8_an[0]:B s9_an[0:2]:B vddd:B
*+ vss5v0:B gpio_ie[11:0]:O gpio_schmitt[11:0]:O gpio_slew[11:0]:O gpio_pullup[11:0]:O gpio_pulldown[11:0]:O SDO_zero:I SDI_zero:I SCK_zero:I
*+ clk_zero:I CSB_zero:I CSB_one:I SDO_pulldown:O SDO_pullup:O SDO_slew:O SDO_schmitt:O SDO_ie:O CSB_pulldown:O CSB_pullup:O SCK_pulldown:O
*+ SCK_pullup:O SDI_pulldown:O SDI_pullup:O clk_pulldown:O clk_pullup:O vss5v0_slot8:B vss5v0_slot2:B vss3v3_slot17:B vss3v3_slot11:B
*+ vss5v0_slot12_13:B vss5v0_slot14_15:B vss3v3_slot4_5:B vss3v3_slot6_7:B
x18 CSB_in SCK_in SDI_in SDO_out bandgap_ena biasgen_coarse biasgen_ena biasgen_fine biasgen_ref_vbg clk_in clk_out porb
+ proj_3v3_ena proj_5v0_ena proj_dig_ena proj_ena proj_vbias_ena project_zero reset SDO_ena sram_clk sram_writeb voltgen_high vddd vss3v3
+ analog_ena[3] analog_ena[2] analog_ena[1] analog_ena[0] bandgap_sink1[2] bandgap_sink1[1] bandgap_sink1[0] bandgap_sink2[1] bandgap_sink2[0]
+ bandgap_trim[15] bandgap_trim[14] bandgap_trim[13] bandgap_trim[12] bandgap_trim[11] bandgap_trim[10] bandgap_trim[9] bandgap_trim[8]
+ bandgap_trim[7] bandgap_trim[6] bandgap_trim[5] bandgap_trim[4] bandgap_trim[3] bandgap_trim[2] bandgap_trim[1] bandgap_trim[0] dbus_in_left[11]
+ dbus_in_left[10] dbus_in_left[9] dbus_in_left[8] dbus_in_left[7] dbus_in_left[6] dbus_in_left[5] dbus_in_left[4] dbus_in_left[3] dbus_in_left[2]
+ dbus_in_left[1] dbus_in_left[0] dbus_in_right[11] dbus_in_right[10] dbus_in_right[9] dbus_in_right[8] dbus_in_right[7] dbus_in_right[6]
+ dbus_in_right[5] dbus_in_right[4] dbus_in_right[3] dbus_in_right[2] dbus_in_right[1] dbus_in_right[0] dbus_out[23] dbus_out[22] dbus_out[21]
+ dbus_out[20] dbus_out[19] dbus_out[18] dbus_out[17] dbus_out[16] dbus_out[15] dbus_out[14] dbus_out[13] dbus_out[12] dbus_out[11] dbus_out[10]
+ dbus_out[9] dbus_out[8] dbus_out[7] dbus_out[6] dbus_out[5] dbus_out[4] dbus_out[3] dbus_out[2] dbus_out[1] dbus_out[0] idac1_value[4]
+ idac1_value[3] idac1_value[2] idac1_value[1] idac1_value[0] idac2_value[4] idac2_value[3] idac2_value[2] idac2_value[1] idac2_value[0]
+ gpio_ie[11] gpio_ie[10] gpio_ie[9] gpio_ie[8] gpio_ie[7] gpio_ie[6] gpio_ie[5] gpio_ie[4] gpio_ie[3] gpio_ie[2] gpio_ie[1] gpio_ie[0]
+ gpio_in[11] gpio_in[10] gpio_in[9] gpio_in[8] gpio_in[7] gpio_in[6] gpio_in[5] gpio_in[4] gpio_in[3] gpio_in[2] gpio_in[1] gpio_in[0]
+ gpio_oe[11] gpio_oe[10] gpio_oe[9] gpio_oe[8] gpio_oe[7] gpio_oe[6] gpio_oe[5] gpio_oe[4] gpio_oe[3] gpio_oe[2] gpio_oe[1] gpio_oe[0]
+ gpio_out[11] gpio_out[10] gpio_out[9] gpio_out[8] gpio_out[7] gpio_out[6] gpio_out[5] gpio_out[4] gpio_out[3] gpio_out[2] gpio_out[1]
+ gpio_out[0] gpio_pulldown[11] gpio_pulldown[10] gpio_pulldown[9] gpio_pulldown[8] gpio_pulldown[7] gpio_pulldown[6] gpio_pulldown[5]
+ gpio_pulldown[4] gpio_pulldown[3] gpio_pulldown[2] gpio_pulldown[1] gpio_pulldown[0] gpio_pullup[11] gpio_pullup[10] gpio_pullup[9] gpio_pullup[8]
+ gpio_pullup[7] gpio_pullup[6] gpio_pullup[5] gpio_pullup[4] gpio_pullup[3] gpio_pullup[2] gpio_pullup[1] gpio_pullup[0] gpio_schmitt[11]
+ gpio_schmitt[10] gpio_schmitt[9] gpio_schmitt[8] gpio_schmitt[7] gpio_schmitt[6] gpio_schmitt[5] gpio_schmitt[4] gpio_schmitt[3] gpio_schmitt[2]
+ gpio_schmitt[1] gpio_schmitt[0] gpio_slew[11] gpio_slew[10] gpio_slew[9] gpio_slew[8] gpio_slew[7] gpio_slew[6] gpio_slew[5] gpio_slew[4]
+ gpio_slew[3] gpio_slew[2] gpio_slew[1] gpio_slew[0] mask_rev[31] mask_rev[30] mask_rev[29] mask_rev[28] mask_rev[27] mask_rev[26] mask_rev[25]
+ mask_rev[24] mask_rev[23] mask_rev[22] mask_rev[21] mask_rev[20] mask_rev[19] mask_rev[18] mask_rev[17] mask_rev[16] mask_rev[15] mask_rev[14]
+ mask_rev[13] mask_rev[12] mask_rev[11] mask_rev[10] mask_rev[9] mask_rev[8] mask_rev[7] mask_rev[6] mask_rev[5] mask_rev[4] mask_rev[3]
+ mask_rev[2] mask_rev[1] mask_rev[0] proj_ibias_ena[1] proj_ibias_ena[0] proj_sel[4] proj_sel[3] proj_sel[2] proj_sel[1] proj_sel[0]
+ sram_addr[9] sram_addr[8] sram_addr[7] sram_addr[6] sram_addr[5] sram_addr[4] sram_addr[3] sram_addr[2] sram_addr[1] sram_addr[0]
+ sram_idata[7] sram_idata[6] sram_idata[5] sram_idata[4] sram_idata[3] sram_idata[2] sram_idata[1] sram_idata[0] sram_odata[7] sram_odata[6]
+ sram_odata[5] sram_odata[4] sram_odata[3] sram_odata[2] sram_odata[1] sram_odata[0] voltgen_ena[2] voltgen_ena[1] voltgen_ena[0]
+ voltgen_sink1[2] voltgen_sink1[1] voltgen_sink1[0] voltgen_sink2[2] voltgen_sink2[1] voltgen_sink2[0] voltgen_source[4] voltgen_source[3]
+ voltgen_source[2] voltgen_source[1] voltgen_source[0] voltgen_value[2] voltgen_value[1] voltgen_value[0] housekeeping_top
x22 biasgen_ena vdd5v0 vss5v0 vdd5v0 vdd3v3 vbg biasgen_ref_vbg vss3v3 bandgap_sink2[1] bandgap_sink2[0] voltgen_source[4]
+ voltgen_source[3] voltgen_source[2] voltgen_source[1] voltgen_source[0] net239 voltgen_sink1[2] voltgen_sink1[1] voltgen_sink1[0] net4
+ idac1_value[4] idac1_value[3] idac1_value[2] idac1_value[1] idac1_value[0] net2 idac1_source idac2_source idac2_value[4] idac2_value[3]
+ idac2_value[2] idac2_value[1] idac2_value[0] biasgen_coarse biasgen_fine bandgap_sink1[2] bandgap_sink1[1] bandgap_sink1[0] net238
+ voltgen_sink2[2] voltgen_sink2[1] voltgen_sink2[0] net3 gf180mcu_ocd_ip__biasgen
x16 vbg net239 bandgap_trim[15] bandgap_trim[14] bandgap_trim[13] bandgap_trim[12] bandgap_trim[11] bandgap_trim[10]
+ bandgap_trim[9] bandgap_trim[8] bandgap_trim[7] bandgap_trim[6] bandgap_trim[5] bandgap_trim[4] bandgap_trim[3] bandgap_trim[2] bandgap_trim[1]
+ bandgap_trim[0] vss3v3 vdd3v3 bandgap_ena net238 gf180mcu_ocd_ip__bandgap
x15[1] vdd3v3 vss3v3 vdd5v0 ibias10[1] vss5v0 net10[1] idac2_source analog_pswitch_small
x15[0] vdd3v3 vss3v3 vdd5v0 ibias10[0] vss5v0 net10[0] idac1_source analog_pswitch_small
x17 vdd3v3 vss3v3 vdd5v0 vbias10 vss5v0 net11 voltgen_vout analog_switch_small
x23[3] vdd3v3 vss3v3 vdd5v0 ana10[3] vss5v0 net9[3] analog[3] analog_switch_med
x23[2] vdd3v3 vss3v3 vdd5v0 ana10[2] vss5v0 net9[2] analog[2] analog_switch_med
x23[1] vdd3v3 vss3v3 vdd5v0 ana10[1] vss5v0 net9[1] analog[1] analog_switch_med
x23[0] vdd3v3 vss3v3 vdd5v0 ana10[0] vss5v0 net9[0] analog[0] analog_switch_med
x25 net8 vdd3v3 vss3v3 net7 power_stage3v3
x7 net6 vdd5v0 vss5v0 vss3v3 vdd3v3 net72 power_stage
x20 vdd3v3 vdd3v3 net5 vss3v3 porb por gf180mcu_ocd_ip__por
* noconn #net5
x26 vss3v3 vddd sram_addr[9] sram_addr[8] sram_addr[7] sram_addr[6] sram_addr[5] sram_addr[4] sram_addr[3] sram_addr[2]
+ sram_addr[1] sram_addr[0] sram_clk sram_writeb sram_odata[7] sram_odata[6] sram_odata[5] sram_odata[4] sram_odata[3] sram_odata[2]
+ sram_odata[1] sram_odata[0] vss3v3 vss3v3 vss3v3 vss3v3 vss3v3 vss3v3 vss3v3 vss3v3 sram_idata[7] sram_idata[6] sram_idata[5] sram_idata[4]
+ sram_idata[3] sram_idata[2] sram_idata[1] sram_idata[0] por gf180mcu_ocd_ip_sram__sram1024x8m8wm1
x27 clk_out proj_dig_ena proj_ena proj_3v3_ena proj_5v0_ena net8 net6 net140 net141 net139 net11 reset proj_vbias_ena vdd3v3
+ vss3v3 analog_ena[3] analog_ena[2] analog_ena[1] analog_ena[0] dbus_out[23] dbus_out[22] dbus_out[21] dbus_out[20] dbus_out[19]
+ dbus_out[18] dbus_out[17] dbus_out[16] dbus_out[15] dbus_out[14] dbus_out[13] dbus_out[12] dbus_out[11] dbus_out[10] dbus_out[9] dbus_out[8]
+ dbus_out[7] dbus_out[6] dbus_out[5] dbus_out[4] dbus_out[3] dbus_out[2] dbus_out[1] dbus_out[0] net14[11] net14[10] net14[9] net14[8]
+ net14[7] net14[6] net14[5] net14[4] net14[3] net14[2] net14[1] net14[0] vss3v3 vss3v3 vss3v3 vss3v3 vss3v3 vss3v3 vss3v3 vss3v3 vss3v3
+ vss3v3 vss3v3 vss3v3 proj_ibias_ena[1] proj_ibias_ena[0] vss3v3 vdd3v3 vss3v3 vdd3v3 vss3v3 net9[3] net9[2] net9[1] net9[0] net12[23]
+ net12[22] net12[21] net12[20] net12[19] net12[18] net12[17] net12[16] net12[15] net12[14] net12[13] net12[12] net12[11] net12[10] net12[9]
+ net12[8] net12[7] net12[6] net12[5] net12[4] net12[3] net12[2] net12[1] net12[0] net13[11] net13[10] net13[9] net13[8] net13[7] net13[6]
+ net13[5] net13[4] net13[3] net13[2] net13[1] net13[0] net10[1] net10[0] proj_sel[4] proj_sel[3] proj_sel[2] proj_sel[1] proj_sel[0]
+ user_project_control
x98 vdd3v3 vss3v3 vdd5v0 analog[1] vss5v0 project_zero idac1_source analog_pswitch_small
x97 vdd3v3 vss3v3 vdd5v0 analog[3] vss5v0 project_zero vbg analog_switch_small
x5[1] vdd3v3 vss3v3 vdd5v0 ibias11[1] vss5v0 net18[1] idac2_source analog_pswitch_small
x5[0] vdd3v3 vss3v3 vdd5v0 ibias11[0] vss5v0 net18[0] idac1_source analog_pswitch_small
x6 vdd3v3 vss3v3 vdd5v0 vbias11 vss5v0 net19 voltgen_vout analog_switch_small
x6[3] vdd3v3 vss3v3 vdd5v0 ana11[3] vss5v0 net17[3] analog[3] analog_switch_med
x6[2] vdd3v3 vss3v3 vdd5v0 ana11[2] vss5v0 net17[2] analog[2] analog_switch_med
x6[1] vdd3v3 vss3v3 vdd5v0 ana11[1] vss5v0 net17[1] analog[1] analog_switch_med
x6[0] vdd3v3 vss3v3 vdd5v0 ana11[0] vss5v0 net17[0] analog[0] analog_switch_med
x8 net16 vdd3v3 vss3v3 net142 power_stage3v3
x9 net15 vdd5v0 vss5v0 vss3v3 vdd3v3 net144 power_stage
x10 clk_out proj_dig_ena proj_ena proj_3v3_ena proj_5v0_ena net16 net15 net146 net147 net145 net19 reset proj_vbias_ena vdd3v3
+ vss3v3 analog_ena[3] analog_ena[2] analog_ena[1] analog_ena[0] dbus_out[23] dbus_out[22] dbus_out[21] dbus_out[20] dbus_out[19]
+ dbus_out[18] dbus_out[17] dbus_out[16] dbus_out[15] dbus_out[14] dbus_out[13] dbus_out[12] dbus_out[11] dbus_out[10] dbus_out[9] dbus_out[8]
+ dbus_out[7] dbus_out[6] dbus_out[5] dbus_out[4] dbus_out[3] dbus_out[2] dbus_out[1] dbus_out[0] net21[11] net21[10] net21[9] net21[8]
+ net21[7] net21[6] net21[5] net21[4] net21[3] net21[2] net21[1] net21[0] net14[11] net14[10] net14[9] net14[8] net14[7] net14[6] net14[5]
+ net14[4] net14[3] net14[2] net14[1] net14[0] proj_ibias_ena[1] proj_ibias_ena[0] vss3v3 vdd3v3 vss3v3 vdd3v3 vdd3v3 net17[3] net17[2]
+ net17[1] net17[0] net143[23] net143[22] net143[21] net143[20] net143[19] net143[18] net143[17] net143[16] net143[15] net143[14] net143[13]
+ net143[12] net143[11] net143[10] net143[9] net143[8] net143[7] net143[6] net143[5] net143[4] net143[3] net143[2] net143[1] net143[0]
+ net20[11] net20[10] net20[9] net20[8] net20[7] net20[6] net20[5] net20[4] net20[3] net20[2] net20[1] net20[0] net18[1] net18[0] proj_sel[4]
+ proj_sel[3] proj_sel[2] proj_sel[1] proj_sel[0] user_project_control
x7[1] vdd3v3 vss3v3 vdd5v0 ibias12[1] vss5v0 net25[1] idac2_source analog_pswitch_small
x7[0] vdd3v3 vss3v3 vdd5v0 ibias12[0] vss5v0 net25[0] idac1_source analog_pswitch_small
x12 vdd3v3 vss3v3 vdd5v0 vbias12 vss5v0 net26 voltgen_vout analog_switch_small
x8[3] vdd3v3 vss3v3 vdd5v0 ana12[3] vss5v0 net24[3] analog[3] analog_switch_med
x8[2] vdd3v3 vss3v3 vdd5v0 ana12[2] vss5v0 net24[2] analog[2] analog_switch_med
x8[1] vdd3v3 vss3v3 vdd5v0 ana12[1] vss5v0 net24[1] analog[1] analog_switch_med
x8[0] vdd3v3 vss3v3 vdd5v0 ana12[0] vss5v0 net24[0] analog[0] analog_switch_med
x13 net23 vdd3v3 vss3v3 net148 power_stage3v3
x14 net22 vdd5v0 vss5v0 vss3v3 vdd3v3 net150 power_stage
x15 clk_out proj_dig_ena proj_ena proj_3v3_ena proj_5v0_ena net23 net22 net152 net153 net151 net26 reset proj_vbias_ena vdd3v3
+ vss3v3 analog_ena[3] analog_ena[2] analog_ena[1] analog_ena[0] dbus_out[23] dbus_out[22] dbus_out[21] dbus_out[20] dbus_out[19]
+ dbus_out[18] dbus_out[17] dbus_out[16] dbus_out[15] dbus_out[14] dbus_out[13] dbus_out[12] dbus_out[11] dbus_out[10] dbus_out[9] dbus_out[8]
+ dbus_out[7] dbus_out[6] dbus_out[5] dbus_out[4] dbus_out[3] dbus_out[2] dbus_out[1] dbus_out[0] net28[11] net28[10] net28[9] net28[8]
+ net28[7] net28[6] net28[5] net28[4] net28[3] net28[2] net28[1] net28[0] net21[11] net21[10] net21[9] net21[8] net21[7] net21[6] net21[5]
+ net21[4] net21[3] net21[2] net21[1] net21[0] proj_ibias_ena[1] proj_ibias_ena[0] vss3v3 vdd3v3 vdd3v3 vss3v3 vss3v3 net24[3] net24[2]
+ net24[1] net24[0] net149[23] net149[22] net149[21] net149[20] net149[19] net149[18] net149[17] net149[16] net149[15] net149[14] net149[13]
+ net149[12] net149[11] net149[10] net149[9] net149[8] net149[7] net149[6] net149[5] net149[4] net149[3] net149[2] net149[1] net149[0]
+ net27[11] net27[10] net27[9] net27[8] net27[7] net27[6] net27[5] net27[4] net27[3] net27[2] net27[1] net27[0] net25[1] net25[0] proj_sel[4]
+ proj_sel[3] proj_sel[2] proj_sel[1] proj_sel[0] user_project_control
x3[1] vdd3v3 vss3v3 vdd5v0 ibias13[1] vss5v0 net32[1] idac2_source analog_pswitch_small
x3[0] vdd3v3 vss3v3 vdd5v0 ibias13[0] vss5v0 net32[0] idac1_source analog_pswitch_small
x1 vdd3v3 vss3v3 vdd5v0 vbias13 vss5v0 net33 voltgen_vout analog_switch_small
x4[3] vdd3v3 vss3v3 vdd5v0 ana13[3] vss5v0 net31[3] analog[3] analog_switch_med
x4[2] vdd3v3 vss3v3 vdd5v0 ana13[2] vss5v0 net31[2] analog[2] analog_switch_med
x4[1] vdd3v3 vss3v3 vdd5v0 ana13[1] vss5v0 net31[1] analog[1] analog_switch_med
x4[0] vdd3v3 vss3v3 vdd5v0 ana13[0] vss5v0 net31[0] analog[0] analog_switch_med
x2 net30 vdd3v3 vss3v3 net154 power_stage3v3
x3 net29 vdd5v0 vss5v0 vss3v3 vdd3v3 net156 power_stage
x4 clk_out proj_dig_ena proj_ena proj_3v3_ena proj_5v0_ena net30 net29 net158 net159 net157 net33 reset proj_vbias_ena vdd3v3
+ vss3v3 analog_ena[3] analog_ena[2] analog_ena[1] analog_ena[0] dbus_out[23] dbus_out[22] dbus_out[21] dbus_out[20] dbus_out[19]
+ dbus_out[18] dbus_out[17] dbus_out[16] dbus_out[15] dbus_out[14] dbus_out[13] dbus_out[12] dbus_out[11] dbus_out[10] dbus_out[9] dbus_out[8]
+ dbus_out[7] dbus_out[6] dbus_out[5] dbus_out[4] dbus_out[3] dbus_out[2] dbus_out[1] dbus_out[0] net35[11] net35[10] net35[9] net35[8]
+ net35[7] net35[6] net35[5] net35[4] net35[3] net35[2] net35[1] net35[0] net28[11] net28[10] net28[9] net28[8] net28[7] net28[6] net28[5]
+ net28[4] net28[3] net28[2] net28[1] net28[0] proj_ibias_ena[1] proj_ibias_ena[0] vss3v3 vdd3v3 vdd3v3 vss3v3 vdd3v3 net31[3] net31[2]
+ net31[1] net31[0] net155[23] net155[22] net155[21] net155[20] net155[19] net155[18] net155[17] net155[16] net155[15] net155[14] net155[13]
+ net155[12] net155[11] net155[10] net155[9] net155[8] net155[7] net155[6] net155[5] net155[4] net155[3] net155[2] net155[1] net155[0]
+ net34[11] net34[10] net34[9] net34[8] net34[7] net34[6] net34[5] net34[4] net34[3] net34[2] net34[1] net34[0] net32[1] net32[0] proj_sel[4]
+ proj_sel[3] proj_sel[2] proj_sel[1] proj_sel[0] user_project_control
x9[1] vdd3v3 vss3v3 vdd5v0 ibias14[1] vss5v0 net39[1] idac2_source analog_pswitch_small
x9[0] vdd3v3 vss3v3 vdd5v0 ibias14[0] vss5v0 net39[0] idac1_source analog_pswitch_small
x23 vdd3v3 vss3v3 vdd5v0 vbias14 vss5v0 net40 voltgen_vout analog_switch_small
x10[3] vdd3v3 vss3v3 vdd5v0 ana14[3] vss5v0 net38[3] analog[3] analog_switch_med
x10[2] vdd3v3 vss3v3 vdd5v0 ana14[2] vss5v0 net38[2] analog[2] analog_switch_med
x10[1] vdd3v3 vss3v3 vdd5v0 ana14[1] vss5v0 net38[1] analog[1] analog_switch_med
x10[0] vdd3v3 vss3v3 vdd5v0 ana14[0] vss5v0 net38[0] analog[0] analog_switch_med
x24 net37 vdd3v3 vss3v3 net160 power_stage3v3
x29 net36 vdd5v0 vss5v0 vss3v3 vdd3v3 net162 power_stage
x30 clk_out proj_dig_ena proj_ena proj_3v3_ena proj_5v0_ena net37 net36 net164 net165 net163 net40 reset proj_vbias_ena vdd3v3
+ vss3v3 analog_ena[3] analog_ena[2] analog_ena[1] analog_ena[0] dbus_out[23] dbus_out[22] dbus_out[21] dbus_out[20] dbus_out[19]
+ dbus_out[18] dbus_out[17] dbus_out[16] dbus_out[15] dbus_out[14] dbus_out[13] dbus_out[12] dbus_out[11] dbus_out[10] dbus_out[9] dbus_out[8]
+ dbus_out[7] dbus_out[6] dbus_out[5] dbus_out[4] dbus_out[3] dbus_out[2] dbus_out[1] dbus_out[0] net42[11] net42[10] net42[9] net42[8]
+ net42[7] net42[6] net42[5] net42[4] net42[3] net42[2] net42[1] net42[0] net35[11] net35[10] net35[9] net35[8] net35[7] net35[6] net35[5]
+ net35[4] net35[3] net35[2] net35[1] net35[0] proj_ibias_ena[1] proj_ibias_ena[0] vss3v3 vdd3v3 vdd3v3 vdd3v3 vss3v3 net38[3] net38[2]
+ net38[1] net38[0] net161[23] net161[22] net161[21] net161[20] net161[19] net161[18] net161[17] net161[16] net161[15] net161[14] net161[13]
+ net161[12] net161[11] net161[10] net161[9] net161[8] net161[7] net161[6] net161[5] net161[4] net161[3] net161[2] net161[1] net161[0]
+ net41[11] net41[10] net41[9] net41[8] net41[7] net41[6] net41[5] net41[4] net41[3] net41[2] net41[1] net41[0] net39[1] net39[0] proj_sel[4]
+ proj_sel[3] proj_sel[2] proj_sel[1] proj_sel[0] user_project_control
x11[1] vdd3v3 vss3v3 vdd5v0 ibias15[1] vss5v0 net46[1] idac2_source analog_pswitch_small
x11[0] vdd3v3 vss3v3 vdd5v0 ibias15[0] vss5v0 net46[0] idac1_source analog_pswitch_small
x32 vdd3v3 vss3v3 vdd5v0 vbias15 vss5v0 net47 voltgen_vout analog_switch_small
x12[3] vdd3v3 vss3v3 vdd5v0 ana15[3] vss5v0 net45[3] analog[3] analog_switch_med
x12[2] vdd3v3 vss3v3 vdd5v0 ana15[2] vss5v0 net45[2] analog[2] analog_switch_med
x12[1] vdd3v3 vss3v3 vdd5v0 ana15[1] vss5v0 net45[1] analog[1] analog_switch_med
x12[0] vdd3v3 vss3v3 vdd5v0 ana15[0] vss5v0 net45[0] analog[0] analog_switch_med
x33 net44 vdd3v3 vss3v3 net172 power_stage3v3
x34 net43 vdd5v0 vss5v0 vss3v3 vdd3v3 net173 power_stage
x35 clk_out proj_dig_ena proj_ena proj_3v3_ena proj_5v0_ena net44 net43 net175 net176 net174 net47 reset proj_vbias_ena vdd3v3
+ vss3v3 analog_ena[3] analog_ena[2] analog_ena[1] analog_ena[0] dbus_out[23] dbus_out[22] dbus_out[21] dbus_out[20] dbus_out[19]
+ dbus_out[18] dbus_out[17] dbus_out[16] dbus_out[15] dbus_out[14] dbus_out[13] dbus_out[12] dbus_out[11] dbus_out[10] dbus_out[9] dbus_out[8]
+ dbus_out[7] dbus_out[6] dbus_out[5] dbus_out[4] dbus_out[3] dbus_out[2] dbus_out[1] dbus_out[0] net50[11] net50[10] net50[9] net50[8]
+ net50[7] net50[6] net50[5] net50[4] net50[3] net50[2] net50[1] net50[0] net42[11] net42[10] net42[9] net42[8] net42[7] net42[6] net42[5]
+ net42[4] net42[3] net42[2] net42[1] net42[0] proj_ibias_ena[1] proj_ibias_ena[0] vss3v3 vdd3v3 vdd3v3 vdd3v3 vdd3v3 net45[3] net45[2]
+ net45[1] net45[0] net48[23] net48[22] net48[21] net48[20] net48[19] net48[18] net48[17] net48[16] net48[15] net48[14] net48[13] net48[12]
+ net48[11] net48[10] net48[9] net48[8] net48[7] net48[6] net48[5] net48[4] net48[3] net48[2] net48[1] net48[0] net49[11] net49[10] net49[9]
+ net49[8] net49[7] net49[6] net49[5] net49[4] net49[3] net49[2] net49[1] net49[0] net46[1] net46[0] proj_sel[4] proj_sel[3] proj_sel[2]
+ proj_sel[1] proj_sel[0] user_project_control
x13[1] vdd3v3 vss3v3 vdd5v0 ibias16[1] vss5v0 net54[1] idac2_source analog_pswitch_small
x13[0] vdd3v3 vss3v3 vdd5v0 ibias16[0] vss5v0 net54[0] idac1_source analog_pswitch_small
x37 vdd3v3 vss3v3 vdd5v0 vbias16 vss5v0 net55 voltgen_vout analog_switch_small
x14[3] vdd3v3 vss3v3 vdd5v0 ana16[3] vss5v0 net53[3] analog[3] analog_switch_med
x14[2] vdd3v3 vss3v3 vdd5v0 ana16[2] vss5v0 net53[2] analog[2] analog_switch_med
x14[1] vdd3v3 vss3v3 vdd5v0 ana16[1] vss5v0 net53[1] analog[1] analog_switch_med
x14[0] vdd3v3 vss3v3 vdd5v0 ana16[0] vss5v0 net53[0] analog[0] analog_switch_med
x38 net52 vdd3v3 vss3v3 net166 power_stage3v3
x39 net51 vdd5v0 vss5v0 vss3v3 vdd3v3 net168 power_stage
x40 clk_out proj_dig_ena proj_ena proj_3v3_ena proj_5v0_ena net52 net51 net170 net171 net169 net55 reset proj_vbias_ena vdd3v3
+ vss3v3 analog_ena[3] analog_ena[2] analog_ena[1] analog_ena[0] dbus_out[23] dbus_out[22] dbus_out[21] dbus_out[20] dbus_out[19]
+ dbus_out[18] dbus_out[17] dbus_out[16] dbus_out[15] dbus_out[14] dbus_out[13] dbus_out[12] dbus_out[11] dbus_out[10] dbus_out[9] dbus_out[8]
+ dbus_out[7] dbus_out[6] dbus_out[5] dbus_out[4] dbus_out[3] dbus_out[2] dbus_out[1] dbus_out[0] net57[11] net57[10] net57[9] net57[8]
+ net57[7] net57[6] net57[5] net57[4] net57[3] net57[2] net57[1] net57[0] net50[11] net50[10] net50[9] net50[8] net50[7] net50[6] net50[5]
+ net50[4] net50[3] net50[2] net50[1] net50[0] proj_ibias_ena[1] proj_ibias_ena[0] vdd3v3 vss3v3 vss3v3 vss3v3 vss3v3 net53[3] net53[2]
+ net53[1] net53[0] net167[23] net167[22] net167[21] net167[20] net167[19] net167[18] net167[17] net167[16] net167[15] net167[14] net167[13]
+ net167[12] net167[11] net167[10] net167[9] net167[8] net167[7] net167[6] net167[5] net167[4] net167[3] net167[2] net167[1] net167[0]
+ net56[11] net56[10] net56[9] net56[8] net56[7] net56[6] net56[5] net56[4] net56[3] net56[2] net56[1] net56[0] net54[1] net54[0] proj_sel[4]
+ proj_sel[3] proj_sel[2] proj_sel[1] proj_sel[0] user_project_control
x16[1] vdd3v3 vss3v3 vdd5v0 ibias17[1] vss5v0 net62[1] idac2_source analog_pswitch_small
x16[0] vdd3v3 vss3v3 vdd5v0 ibias17[0] vss5v0 net62[0] idac1_source analog_pswitch_small
x42 vdd3v3 vss3v3 vdd5v0 vbias17 vss5v0 net63 voltgen_vout analog_switch_small
x17[3] vdd3v3 vss3v3 vdd5v0 ana17[3] vss5v0 net61[3] analog[3] analog_switch_med
x17[2] vdd3v3 vss3v3 vdd5v0 ana17[2] vss5v0 net61[2] analog[2] analog_switch_med
x17[1] vdd3v3 vss3v3 vdd5v0 ana17[1] vss5v0 net61[1] analog[1] analog_switch_med
x17[0] vdd3v3 vss3v3 vdd5v0 ana17[0] vss5v0 net61[0] analog[0] analog_switch_med
x43 net60 vdd3v3 vss3v3 net59 power_stage3v3
x44 net58 vdd5v0 vss5v0 vss3v3 vdd3v3 net73 power_stage
x45 clk_out proj_dig_ena proj_ena proj_3v3_ena proj_5v0_ena net60 net58 net179 net180 net178 net63 reset proj_vbias_ena vdd3v3
+ vss3v3 analog_ena[3] analog_ena[2] analog_ena[1] analog_ena[0] dbus_out[23] dbus_out[22] dbus_out[21] dbus_out[20] dbus_out[19]
+ dbus_out[18] dbus_out[17] dbus_out[16] dbus_out[15] dbus_out[14] dbus_out[13] dbus_out[12] dbus_out[11] dbus_out[10] dbus_out[9] dbus_out[8]
+ dbus_out[7] dbus_out[6] dbus_out[5] dbus_out[4] dbus_out[3] dbus_out[2] dbus_out[1] dbus_out[0] net65[11] net65[10] net65[9] net65[8]
+ net65[7] net65[6] net65[5] net65[4] net65[3] net65[2] net65[1] net65[0] net57[11] net57[10] net57[9] net57[8] net57[7] net57[6] net57[5]
+ net57[4] net57[3] net57[2] net57[1] net57[0] proj_ibias_ena[1] proj_ibias_ena[0] vdd3v3 vss3v3 vss3v3 vss3v3 vdd3v3 net61[3] net61[2]
+ net61[1] net61[0] net177[23] net177[22] net177[21] net177[20] net177[19] net177[18] net177[17] net177[16] net177[15] net177[14] net177[13]
+ net177[12] net177[11] net177[10] net177[9] net177[8] net177[7] net177[6] net177[5] net177[4] net177[3] net177[2] net177[1] net177[0]
+ net64[11] net64[10] net64[9] net64[8] net64[7] net64[6] net64[5] net64[4] net64[3] net64[2] net64[1] net64[0] net62[1] net62[0] proj_sel[4]
+ proj_sel[3] proj_sel[2] proj_sel[1] proj_sel[0] user_project_control
x18[1] vdd3v3 vss3v3 vdd5v0 ibias18[1] vss5v0 net69[1] idac2_source analog_pswitch_small
x18[0] vdd3v3 vss3v3 vdd5v0 ibias18[0] vss5v0 net69[0] idac1_source analog_pswitch_small
x47 vdd3v3 vss3v3 vdd5v0 vbias18 vss5v0 net70 voltgen_vout analog_switch_small
x19[3] vdd3v3 vss3v3 vdd5v0 ana18[3] vss5v0 net68[3] analog[3] analog_switch_med
x19[2] vdd3v3 vss3v3 vdd5v0 ana18[2] vss5v0 net68[2] analog[2] analog_switch_med
x19[1] vdd3v3 vss3v3 vdd5v0 ana18[1] vss5v0 net68[1] analog[1] analog_switch_med
x19[0] vdd3v3 vss3v3 vdd5v0 ana18[0] vss5v0 net68[0] analog[0] analog_switch_med
x48 net67 vdd3v3 vss3v3 net186 power_stage3v3
x49 net66 vdd5v0 vss5v0 vss3v3 vdd3v3 net183 power_stage
x50 clk_out proj_dig_ena proj_ena proj_3v3_ena proj_5v0_ena net67 net66 net184 net185 net182 net70 reset proj_vbias_ena vdd3v3
+ vss3v3 analog_ena[3] analog_ena[2] analog_ena[1] analog_ena[0] dbus_out[23] dbus_out[22] dbus_out[21] dbus_out[20] dbus_out[19]
+ dbus_out[18] dbus_out[17] dbus_out[16] dbus_out[15] dbus_out[14] dbus_out[13] dbus_out[12] dbus_out[11] dbus_out[10] dbus_out[9] dbus_out[8]
+ dbus_out[7] dbus_out[6] dbus_out[5] dbus_out[4] dbus_out[3] dbus_out[2] dbus_out[1] dbus_out[0] dbus_in_left[11] dbus_in_left[10]
+ dbus_in_left[9] dbus_in_left[8] dbus_in_left[7] dbus_in_left[6] dbus_in_left[5] dbus_in_left[4] dbus_in_left[3] dbus_in_left[2] dbus_in_left[1]
+ dbus_in_left[0] net65[11] net65[10] net65[9] net65[8] net65[7] net65[6] net65[5] net65[4] net65[3] net65[2] net65[1] net65[0] proj_ibias_ena[1]
+ proj_ibias_ena[0] vdd3v3 vss3v3 vss3v3 vdd3v3 vss3v3 net68[3] net68[2] net68[1] net68[0] net181[23] net181[22] net181[21] net181[20] net181[19]
+ net181[18] net181[17] net181[16] net181[15] net181[14] net181[13] net181[12] net181[11] net181[10] net181[9] net181[8] net181[7] net181[6]
+ net181[5] net181[4] net181[3] net181[2] net181[1] net181[0] net71[11] net71[10] net71[9] net71[8] net71[7] net71[6] net71[5] net71[4]
+ net71[3] net71[2] net71[1] net71[0] net69[1] net69[0] proj_sel[4] proj_sel[3] proj_sel[2] proj_sel[1] proj_sel[0] user_project_control
x5 s18_an[0] s18_an[1] net186 vss5v0 net183 vss3v3 ana18[3] ana18[2] ana18[1] ana18[0] vbias18 ibias18[0] ibias18[1] net71[11]
+ net71[10] net71[9] net71[8] net71[7] net71[6] net71[5] net71[4] net71[3] net71[2] net71[1] net71[0] net181[23] net181[22] net181[21]
+ net181[20] net181[19] net181[18] net181[17] net181[16] net181[15] net181[14] net181[13] net181[12] net181[11] net181[10] net181[9] net181[8]
+ net181[7] net181[6] net181[5] net181[4] net181[3] net181[2] net181[1] net181[0] net182 net185 net184 slot18_wrapper
x11 vss3v3_slot17 s17_an[0] s17_an[1] net59 vss5v0 net73 vss3v3 ana17[3] ana17[2] ana17[1] ana17[0] vbias17 ibias17[0] ibias17[1]
+ net64[11] net64[10] net64[9] net64[8] net64[7] net64[6] net64[5] net64[4] net64[3] net64[2] net64[1] net64[0] net177[23] net177[22]
+ net177[21] net177[20] net177[19] net177[18] net177[17] net177[16] net177[15] net177[14] net177[13] net177[12] net177[11] net177[10]
+ net177[9] net177[8] net177[7] net177[6] net177[5] net177[4] net177[3] net177[2] net177[1] net177[0] net178 net180 net179 slot17_wrapper
x19 s16_an[0] s16_an[1] net166 vss5v0 net168 vss3v3 ana16[3] ana16[2] ana16[1] ana16[0] vbias16 ibias16[0] ibias16[1] net56[11]
+ net56[10] net56[9] net56[8] net56[7] net56[6] net56[5] net56[4] net56[3] net56[2] net56[1] net56[0] net167[23] net167[22] net167[21]
+ net167[20] net167[19] net167[18] net167[17] net167[16] net167[15] net167[14] net167[13] net167[12] net167[11] net167[10] net167[9] net167[8]
+ net167[7] net167[6] net167[5] net167[4] net167[3] net167[2] net167[1] net167[0] net169 net171 net170 slot16_wrapper
x28 s15_an[0] s15_an[1] net172 vss5v0 net173 vss3v3 ana15[3] ana15[2] ana15[1] ana15[0] vbias15 ibias15[0] ibias15[1] net49[11]
+ net49[10] net49[9] net49[8] net49[7] net49[6] net49[5] net49[4] net49[3] net49[2] net49[1] net49[0] net48[23] net48[22] net48[21] net48[20]
+ net48[19] net48[18] net48[17] net48[16] net48[15] net48[14] net48[13] net48[12] net48[11] net48[10] net48[9] net48[8] net48[7] net48[6]
+ net48[5] net48[4] net48[3] net48[2] net48[1] net48[0] net174 net176 net175 slot15_wrapper
x31 s14_an[0] s14_an[1] net160 vss5v0 net162 vss3v3 ana14[3] ana14[2] ana14[1] ana14[0] vbias14 ibias14[0] ibias14[1] net41[11]
+ net41[10] net41[9] net41[8] net41[7] net41[6] net41[5] net41[4] net41[3] net41[2] net41[1] net41[0] net161[23] net161[22] net161[21]
+ net161[20] net161[19] net161[18] net161[17] net161[16] net161[15] net161[14] net161[13] net161[12] net161[11] net161[10] net161[9] net161[8]
+ net161[7] net161[6] net161[5] net161[4] net161[3] net161[2] net161[1] net161[0] net163 net165 net164 slot14_wrapper
x36 s13_an[0] s13_an[1] net154 vss5v0 net156 vss3v3 ana13[3] ana13[2] ana13[1] ana13[0] vbias13 ibias13[0] ibias13[1] net34[11]
+ net34[10] net34[9] net34[8] net34[7] net34[6] net34[5] net34[4] net34[3] net34[2] net34[1] net34[0] net155[23] net155[22] net155[21]
+ net155[20] net155[19] net155[18] net155[17] net155[16] net155[15] net155[14] net155[13] net155[12] net155[11] net155[10] net155[9] net155[8]
+ net155[7] net155[6] net155[5] net155[4] net155[3] net155[2] net155[1] net155[0] net157 net159 net158 slot13_wrapper
x41 s12_an[0] s12_an[1] net148 vss5v0 net150 vss3v3 ana12[3] ana12[2] ana12[1] ana12[0] vbias12 ibias12[0] ibias12[1] net27[11]
+ net27[10] net27[9] net27[8] net27[7] net27[6] net27[5] net27[4] net27[3] net27[2] net27[1] net27[0] net149[23] net149[22] net149[21]
+ net149[20] net149[19] net149[18] net149[17] net149[16] net149[15] net149[14] net149[13] net149[12] net149[11] net149[10] net149[9] net149[8]
+ net149[7] net149[6] net149[5] net149[4] net149[3] net149[2] net149[1] net149[0] net151 net153 net152 slot12_wrapper
x46 vss3v3_slot11 s11_an[0] net142 vss5v0 net144 vss3v3 ana11[3] ana11[2] ana11[1] ana11[0] vbias11 ibias11[0] ibias11[1]
+ net20[11] net20[10] net20[9] net20[8] net20[7] net20[6] net20[5] net20[4] net20[3] net20[2] net20[1] net20[0] net143[23] net143[22]
+ net143[21] net143[20] net143[19] net143[18] net143[17] net143[16] net143[15] net143[14] net143[13] net143[12] net143[11] net143[10]
+ net143[9] net143[8] net143[7] net143[6] net143[5] net143[4] net143[3] net143[2] net143[1] net143[0] net145 net147 net146 slot11_wrapper
x51 s10_an[0] s10_an[1] s10_an[2] net7 vss5v0 net72 vss3v3 ana10[3] ana10[2] ana10[1] ana10[0] vbias10 ibias10[0] ibias10[1]
+ net13[11] net13[10] net13[9] net13[8] net13[7] net13[6] net13[5] net13[4] net13[3] net13[2] net13[1] net13[0] net12[23] net12[22] net12[21]
+ net12[20] net12[19] net12[18] net12[17] net12[16] net12[15] net12[14] net12[13] net12[12] net12[11] net12[10] net12[9] net12[8] net12[7]
+ net12[6] net12[5] net12[4] net12[3] net12[2] net12[1] net12[0] net139 net141 net140 slot10_wrapper
x20[1] vdd3v3 vss3v3 vdd5v0 ibias9[1] vss5v0 net78[1] idac2_source analog_pswitch_small
x20[0] vdd3v3 vss3v3 vdd5v0 ibias9[0] vss5v0 net78[0] idac1_source analog_pswitch_small
x52 vdd3v3 vss3v3 vdd5v0 vbias9 vss5v0 net79 voltgen_vout analog_switch_small
x21[3] vdd3v3 vss3v3 vdd5v0 ana9[3] vss5v0 net77[3] analog[3] analog_switch_med
x21[2] vdd3v3 vss3v3 vdd5v0 ana9[2] vss5v0 net77[2] analog[2] analog_switch_med
x21[1] vdd3v3 vss3v3 vdd5v0 ana9[1] vss5v0 net77[1] analog[1] analog_switch_med
x21[0] vdd3v3 vss3v3 vdd5v0 ana9[0] vss5v0 net77[0] analog[0] analog_switch_med
x53 net76 vdd3v3 vss3v3 net75 power_stage3v3
x54 net74 vdd5v0 vss5v0 vss3v3 vdd3v3 net137 power_stage
x55 clk_out proj_dig_ena proj_ena proj_3v3_ena proj_5v0_ena net76 net74 net189 net138 net187 net79 reset proj_vbias_ena vdd3v3
+ vss3v3 analog_ena[3] analog_ena[2] analog_ena[1] analog_ena[0] dbus_out[23] dbus_out[22] dbus_out[21] dbus_out[20] dbus_out[19]
+ dbus_out[18] dbus_out[17] dbus_out[16] dbus_out[15] dbus_out[14] dbus_out[13] dbus_out[12] dbus_out[11] dbus_out[10] dbus_out[9] dbus_out[8]
+ dbus_out[7] dbus_out[6] dbus_out[5] dbus_out[4] dbus_out[3] dbus_out[2] dbus_out[1] dbus_out[0] net81[11] net81[10] net81[9] net81[8]
+ net81[7] net81[6] net81[5] net81[4] net81[3] net81[2] net81[1] net81[0] vss3v3 vss3v3 vss3v3 vss3v3 vss3v3 vss3v3 vss3v3 vss3v3 vss3v3
+ vss3v3 vss3v3 vss3v3 proj_ibias_ena[1] proj_ibias_ena[0] vss3v3 vdd3v3 vss3v3 vss3v3 vdd3v3 net77[3] net77[2] net77[1] net77[0]
+ net188[23] net188[22] net188[21] net188[20] net188[19] net188[18] net188[17] net188[16] net188[15] net188[14] net188[13] net188[12]
+ net188[11] net188[10] net188[9] net188[8] net188[7] net188[6] net188[5] net188[4] net188[3] net188[2] net188[1] net188[0] net80[11]
+ net80[10] net80[9] net80[8] net80[7] net80[6] net80[5] net80[4] net80[3] net80[2] net80[1] net80[0] net78[1] net78[0] proj_sel[4]
+ proj_sel[3] proj_sel[2] proj_sel[1] proj_sel[0] user_project_control
x22[1] vdd3v3 vss3v3 vdd5v0 ibias8[1] vss5v0 net85[1] idac2_source analog_pswitch_small
x22[0] vdd3v3 vss3v3 vdd5v0 ibias8[0] vss5v0 net85[0] idac1_source analog_pswitch_small
x56 vdd3v3 vss3v3 vdd5v0 vbias8 vss5v0 net86 voltgen_vout analog_switch_small
x24[3] vdd3v3 vss3v3 vdd5v0 ana8[3] vss5v0 net84[3] analog[3] analog_switch_med
x24[2] vdd3v3 vss3v3 vdd5v0 ana8[2] vss5v0 net84[2] analog[2] analog_switch_med
x24[1] vdd3v3 vss3v3 vdd5v0 ana8[1] vss5v0 net84[1] analog[1] analog_switch_med
x24[0] vdd3v3 vss3v3 vdd5v0 ana8[0] vss5v0 net84[0] analog[0] analog_switch_med
x57 net83 vdd3v3 vss3v3 net190 power_stage3v3
x58 net82 vdd5v0 vss5v0 vss3v3 vdd3v3 net191 power_stage
x59 clk_out proj_dig_ena proj_ena proj_3v3_ena proj_5v0_ena net83 net82 net195 net192 net193 net86 reset proj_vbias_ena vdd3v3
+ vss3v3 analog_ena[3] analog_ena[2] analog_ena[1] analog_ena[0] dbus_out[23] dbus_out[22] dbus_out[21] dbus_out[20] dbus_out[19]
+ dbus_out[18] dbus_out[17] dbus_out[16] dbus_out[15] dbus_out[14] dbus_out[13] dbus_out[12] dbus_out[11] dbus_out[10] dbus_out[9] dbus_out[8]
+ dbus_out[7] dbus_out[6] dbus_out[5] dbus_out[4] dbus_out[3] dbus_out[2] dbus_out[1] dbus_out[0] net88[11] net88[10] net88[9] net88[8]
+ net88[7] net88[6] net88[5] net88[4] net88[3] net88[2] net88[1] net88[0] net81[11] net81[10] net81[9] net81[8] net81[7] net81[6] net81[5]
+ net81[4] net81[3] net81[2] net81[1] net81[0] proj_ibias_ena[1] proj_ibias_ena[0] vss3v3 vdd3v3 vss3v3 vss3v3 vss3v3 net84[3] net84[2]
+ net84[1] net84[0] net194[23] net194[22] net194[21] net194[20] net194[19] net194[18] net194[17] net194[16] net194[15] net194[14] net194[13]
+ net194[12] net194[11] net194[10] net194[9] net194[8] net194[7] net194[6] net194[5] net194[4] net194[3] net194[2] net194[1] net194[0]
+ net87[11] net87[10] net87[9] net87[8] net87[7] net87[6] net87[5] net87[4] net87[3] net87[2] net87[1] net87[0] net85[1] net85[0] proj_sel[4]
+ proj_sel[3] proj_sel[2] proj_sel[1] proj_sel[0] user_project_control
x25[1] vdd3v3 vss3v3 vdd5v0 ibias7[1] vss5v0 net92[1] idac2_source analog_pswitch_small
x25[0] vdd3v3 vss3v3 vdd5v0 ibias7[0] vss5v0 net92[0] idac1_source analog_pswitch_small
x60 vdd3v3 vss3v3 vdd5v0 vbias7 vss5v0 net93 voltgen_vout analog_switch_small
x26[3] vdd3v3 vss3v3 vdd5v0 ana7[3] vss5v0 net91[3] analog[3] analog_switch_med
x26[2] vdd3v3 vss3v3 vdd5v0 ana7[2] vss5v0 net91[2] analog[2] analog_switch_med
x26[1] vdd3v3 vss3v3 vdd5v0 ana7[1] vss5v0 net91[1] analog[1] analog_switch_med
x26[0] vdd3v3 vss3v3 vdd5v0 ana7[0] vss5v0 net91[0] analog[0] analog_switch_med
x61 net90 vdd3v3 vss3v3 net196 power_stage3v3
x62 net89 vdd5v0 vss5v0 vss3v3 vdd3v3 net197 power_stage
x63 clk_out proj_dig_ena proj_ena proj_3v3_ena proj_5v0_ena net90 net89 net201 net198 net199 net93 reset proj_vbias_ena vdd3v3
+ vss3v3 analog_ena[3] analog_ena[2] analog_ena[1] analog_ena[0] dbus_out[23] dbus_out[22] dbus_out[21] dbus_out[20] dbus_out[19]
+ dbus_out[18] dbus_out[17] dbus_out[16] dbus_out[15] dbus_out[14] dbus_out[13] dbus_out[12] dbus_out[11] dbus_out[10] dbus_out[9] dbus_out[8]
+ dbus_out[7] dbus_out[6] dbus_out[5] dbus_out[4] dbus_out[3] dbus_out[2] dbus_out[1] dbus_out[0] net95[11] net95[10] net95[9] net95[8]
+ net95[7] net95[6] net95[5] net95[4] net95[3] net95[2] net95[1] net95[0] net88[11] net88[10] net88[9] net88[8] net88[7] net88[6] net88[5]
+ net88[4] net88[3] net88[2] net88[1] net88[0] proj_ibias_ena[1] proj_ibias_ena[0] vss3v3 vss3v3 vdd3v3 vdd3v3 vdd3v3 net91[3] net91[2]
+ net91[1] net91[0] net200[23] net200[22] net200[21] net200[20] net200[19] net200[18] net200[17] net200[16] net200[15] net200[14] net200[13]
+ net200[12] net200[11] net200[10] net200[9] net200[8] net200[7] net200[6] net200[5] net200[4] net200[3] net200[2] net200[1] net200[0]
+ net94[11] net94[10] net94[9] net94[8] net94[7] net94[6] net94[5] net94[4] net94[3] net94[2] net94[1] net94[0] net92[1] net92[0] proj_sel[4]
+ proj_sel[3] proj_sel[2] proj_sel[1] proj_sel[0] user_project_control
x27[1] vdd3v3 vss3v3 vdd5v0 ibias6[1] vss5v0 net99[1] idac2_source analog_pswitch_small
x27[0] vdd3v3 vss3v3 vdd5v0 ibias6[0] vss5v0 net99[0] idac1_source analog_pswitch_small
x64 vdd3v3 vss3v3 vdd5v0 vbias6 vss5v0 net100 voltgen_vout analog_switch_small
x28[3] vdd3v3 vss3v3 vdd5v0 ana6[3] vss5v0 net98[3] analog[3] analog_switch_med
x28[2] vdd3v3 vss3v3 vdd5v0 ana6[2] vss5v0 net98[2] analog[2] analog_switch_med
x28[1] vdd3v3 vss3v3 vdd5v0 ana6[1] vss5v0 net98[1] analog[1] analog_switch_med
x28[0] vdd3v3 vss3v3 vdd5v0 ana6[0] vss5v0 net98[0] analog[0] analog_switch_med
x65 net97 vdd3v3 vss3v3 net202 power_stage3v3
x66 net96 vdd5v0 vss5v0 vss3v3 vdd3v3 net203 power_stage
x67 clk_out proj_dig_ena proj_ena proj_3v3_ena proj_5v0_ena net97 net96 net207 net204 net205 net100 reset proj_vbias_ena vdd3v3
+ vss3v3 analog_ena[3] analog_ena[2] analog_ena[1] analog_ena[0] dbus_out[23] dbus_out[22] dbus_out[21] dbus_out[20] dbus_out[19]
+ dbus_out[18] dbus_out[17] dbus_out[16] dbus_out[15] dbus_out[14] dbus_out[13] dbus_out[12] dbus_out[11] dbus_out[10] dbus_out[9] dbus_out[8]
+ dbus_out[7] dbus_out[6] dbus_out[5] dbus_out[4] dbus_out[3] dbus_out[2] dbus_out[1] dbus_out[0] net102[11] net102[10] net102[9] net102[8]
+ net102[7] net102[6] net102[5] net102[4] net102[3] net102[2] net102[1] net102[0] net95[11] net95[10] net95[9] net95[8] net95[7] net95[6]
+ net95[5] net95[4] net95[3] net95[2] net95[1] net95[0] proj_ibias_ena[1] proj_ibias_ena[0] vss3v3 vss3v3 vdd3v3 vdd3v3 vss3v3 net98[3]
+ net98[2] net98[1] net98[0] net206[23] net206[22] net206[21] net206[20] net206[19] net206[18] net206[17] net206[16] net206[15] net206[14]
+ net206[13] net206[12] net206[11] net206[10] net206[9] net206[8] net206[7] net206[6] net206[5] net206[4] net206[3] net206[2] net206[1]
+ net206[0] net101[11] net101[10] net101[9] net101[8] net101[7] net101[6] net101[5] net101[4] net101[3] net101[2] net101[1] net101[0]
+ net99[1] net99[0] proj_sel[4] proj_sel[3] proj_sel[2] proj_sel[1] proj_sel[0] user_project_control
x29[1] vdd3v3 vss3v3 vdd5v0 ibias5[1] vss5v0 net106[1] idac2_source analog_pswitch_small
x29[0] vdd3v3 vss3v3 vdd5v0 ibias5[0] vss5v0 net106[0] idac1_source analog_pswitch_small
x68 vdd3v3 vss3v3 vdd5v0 vbias5 vss5v0 net107 voltgen_vout analog_switch_small
x30[3] vdd3v3 vss3v3 vdd5v0 ana5[3] vss5v0 net105[3] analog[3] analog_switch_med
x30[2] vdd3v3 vss3v3 vdd5v0 ana5[2] vss5v0 net105[2] analog[2] analog_switch_med
x30[1] vdd3v3 vss3v3 vdd5v0 ana5[1] vss5v0 net105[1] analog[1] analog_switch_med
x30[0] vdd3v3 vss3v3 vdd5v0 ana5[0] vss5v0 net105[0] analog[0] analog_switch_med
x69 net104 vdd3v3 vss3v3 net208 power_stage3v3
x70 net103 vdd5v0 vss5v0 vss3v3 vdd3v3 net209 power_stage
x71 clk_out proj_dig_ena proj_ena proj_3v3_ena proj_5v0_ena net104 net103 net213 net210 net211 net107 reset proj_vbias_ena vdd3v3
+ vss3v3 analog_ena[3] analog_ena[2] analog_ena[1] analog_ena[0] dbus_out[23] dbus_out[22] dbus_out[21] dbus_out[20] dbus_out[19]
+ dbus_out[18] dbus_out[17] dbus_out[16] dbus_out[15] dbus_out[14] dbus_out[13] dbus_out[12] dbus_out[11] dbus_out[10] dbus_out[9] dbus_out[8]
+ dbus_out[7] dbus_out[6] dbus_out[5] dbus_out[4] dbus_out[3] dbus_out[2] dbus_out[1] dbus_out[0] net109[11] net109[10] net109[9] net109[8]
+ net109[7] net109[6] net109[5] net109[4] net109[3] net109[2] net109[1] net109[0] net102[11] net102[10] net102[9] net102[8] net102[7]
+ net102[6] net102[5] net102[4] net102[3] net102[2] net102[1] net102[0] proj_ibias_ena[1] proj_ibias_ena[0] vss3v3 vss3v3 vdd3v3 vss3v3
+ vdd3v3 net105[3] net105[2] net105[1] net105[0] net212[23] net212[22] net212[21] net212[20] net212[19] net212[18] net212[17] net212[16]
+ net212[15] net212[14] net212[13] net212[12] net212[11] net212[10] net212[9] net212[8] net212[7] net212[6] net212[5] net212[4] net212[3]
+ net212[2] net212[1] net212[0] net108[11] net108[10] net108[9] net108[8] net108[7] net108[6] net108[5] net108[4] net108[3] net108[2]
+ net108[1] net108[0] net106[1] net106[0] proj_sel[4] proj_sel[3] proj_sel[2] proj_sel[1] proj_sel[0] user_project_control
x31[1] vdd3v3 vss3v3 vdd5v0 ibias4[1] vss5v0 net113[1] idac2_source analog_pswitch_small
x31[0] vdd3v3 vss3v3 vdd5v0 ibias4[0] vss5v0 net113[0] idac1_source analog_pswitch_small
x72 vdd3v3 vss3v3 vdd5v0 vbias4 vss5v0 net114 voltgen_vout analog_switch_small
x32[3] vdd3v3 vss3v3 vdd5v0 ana4[3] vss5v0 net112[3] analog[3] analog_switch_med
x32[2] vdd3v3 vss3v3 vdd5v0 ana4[2] vss5v0 net112[2] analog[2] analog_switch_med
x32[1] vdd3v3 vss3v3 vdd5v0 ana4[1] vss5v0 net112[1] analog[1] analog_switch_med
x32[0] vdd3v3 vss3v3 vdd5v0 ana4[0] vss5v0 net112[0] analog[0] analog_switch_med
x73 net111 vdd3v3 vss3v3 net214 power_stage3v3
x74 net110 vdd5v0 vss5v0 vss3v3 vdd3v3 net215 power_stage
x75 clk_out proj_dig_ena proj_ena proj_3v3_ena proj_5v0_ena net111 net110 net219 net216 net217 net114 reset proj_vbias_ena vdd3v3
+ vss3v3 analog_ena[3] analog_ena[2] analog_ena[1] analog_ena[0] dbus_out[23] dbus_out[22] dbus_out[21] dbus_out[20] dbus_out[19]
+ dbus_out[18] dbus_out[17] dbus_out[16] dbus_out[15] dbus_out[14] dbus_out[13] dbus_out[12] dbus_out[11] dbus_out[10] dbus_out[9] dbus_out[8]
+ dbus_out[7] dbus_out[6] dbus_out[5] dbus_out[4] dbus_out[3] dbus_out[2] dbus_out[1] dbus_out[0] net116[11] net116[10] net116[9] net116[8]
+ net116[7] net116[6] net116[5] net116[4] net116[3] net116[2] net116[1] net116[0] net109[11] net109[10] net109[9] net109[8] net109[7]
+ net109[6] net109[5] net109[4] net109[3] net109[2] net109[1] net109[0] proj_ibias_ena[1] proj_ibias_ena[0] vss3v3 vss3v3 vdd3v3 vss3v3
+ vss3v3 net112[3] net112[2] net112[1] net112[0] net218[23] net218[22] net218[21] net218[20] net218[19] net218[18] net218[17] net218[16]
+ net218[15] net218[14] net218[13] net218[12] net218[11] net218[10] net218[9] net218[8] net218[7] net218[6] net218[5] net218[4] net218[3]
+ net218[2] net218[1] net218[0] net115[11] net115[10] net115[9] net115[8] net115[7] net115[6] net115[5] net115[4] net115[3] net115[2]
+ net115[1] net115[0] net113[1] net113[0] proj_sel[4] proj_sel[3] proj_sel[2] proj_sel[1] proj_sel[0] user_project_control
x33[1] vdd3v3 vss3v3 vdd5v0 ibias3[1] vss5v0 net120[1] idac2_source analog_pswitch_small
x33[0] vdd3v3 vss3v3 vdd5v0 ibias3[0] vss5v0 net120[0] idac1_source analog_pswitch_small
x76 vdd3v3 vss3v3 vdd5v0 vbias3 vss5v0 net121 voltgen_vout analog_switch_small
x34[3] vdd3v3 vss3v3 vdd5v0 ana3[3] vss5v0 net119[3] analog[3] analog_switch_med
x34[2] vdd3v3 vss3v3 vdd5v0 ana3[2] vss5v0 net119[2] analog[2] analog_switch_med
x34[1] vdd3v3 vss3v3 vdd5v0 ana3[1] vss5v0 net119[1] analog[1] analog_switch_med
x34[0] vdd3v3 vss3v3 vdd5v0 ana3[0] vss5v0 net119[0] analog[0] analog_switch_med
x77 net118 vdd3v3 vss3v3 net220 power_stage3v3
x78 net117 vdd5v0 vss5v0 vss3v3 vdd3v3 net221 power_stage
x79 clk_out proj_dig_ena proj_ena proj_3v3_ena proj_5v0_ena net118 net117 net225 net222 net223 net121 reset proj_vbias_ena vdd3v3
+ vss3v3 analog_ena[3] analog_ena[2] analog_ena[1] analog_ena[0] dbus_out[23] dbus_out[22] dbus_out[21] dbus_out[20] dbus_out[19]
+ dbus_out[18] dbus_out[17] dbus_out[16] dbus_out[15] dbus_out[14] dbus_out[13] dbus_out[12] dbus_out[11] dbus_out[10] dbus_out[9] dbus_out[8]
+ dbus_out[7] dbus_out[6] dbus_out[5] dbus_out[4] dbus_out[3] dbus_out[2] dbus_out[1] dbus_out[0] net123[11] net123[10] net123[9] net123[8]
+ net123[7] net123[6] net123[5] net123[4] net123[3] net123[2] net123[1] net123[0] net116[11] net116[10] net116[9] net116[8] net116[7]
+ net116[6] net116[5] net116[4] net116[3] net116[2] net116[1] net116[0] proj_ibias_ena[1] proj_ibias_ena[0] vss3v3 vss3v3 vss3v3 vdd3v3
+ vdd3v3 net119[3] net119[2] net119[1] net119[0] net224[23] net224[22] net224[21] net224[20] net224[19] net224[18] net224[17] net224[16]
+ net224[15] net224[14] net224[13] net224[12] net224[11] net224[10] net224[9] net224[8] net224[7] net224[6] net224[5] net224[4] net224[3]
+ net224[2] net224[1] net224[0] net122[11] net122[10] net122[9] net122[8] net122[7] net122[6] net122[5] net122[4] net122[3] net122[2]
+ net122[1] net122[0] net120[1] net120[0] proj_sel[4] proj_sel[3] proj_sel[2] proj_sel[1] proj_sel[0] user_project_control
x35[1] vdd3v3 vss3v3 vdd5v0 ibias2[1] vss5v0 net127[1] idac2_source analog_pswitch_small
x35[0] vdd3v3 vss3v3 vdd5v0 ibias2[0] vss5v0 net127[0] idac1_source analog_pswitch_small
x80 vdd3v3 vss3v3 vdd5v0 vbias2 vss5v0 net128 voltgen_vout analog_switch_small
x36[3] vdd3v3 vss3v3 vdd5v0 ana2[3] vss5v0 net126[3] analog[3] analog_switch_med
x36[2] vdd3v3 vss3v3 vdd5v0 ana2[2] vss5v0 net126[2] analog[2] analog_switch_med
x36[1] vdd3v3 vss3v3 vdd5v0 ana2[1] vss5v0 net126[1] analog[1] analog_switch_med
x36[0] vdd3v3 vss3v3 vdd5v0 ana2[0] vss5v0 net126[0] analog[0] analog_switch_med
x81 net125 vdd3v3 vss3v3 net226 power_stage3v3
x82 net124 vdd5v0 vss5v0 vss3v3 vdd3v3 net227 power_stage
x83 clk_out proj_dig_ena proj_ena proj_3v3_ena proj_5v0_ena net125 net124 net231 net228 net229 net128 reset proj_vbias_ena vdd3v3
+ vss3v3 analog_ena[3] analog_ena[2] analog_ena[1] analog_ena[0] dbus_out[23] dbus_out[22] dbus_out[21] dbus_out[20] dbus_out[19]
+ dbus_out[18] dbus_out[17] dbus_out[16] dbus_out[15] dbus_out[14] dbus_out[13] dbus_out[12] dbus_out[11] dbus_out[10] dbus_out[9] dbus_out[8]
+ dbus_out[7] dbus_out[6] dbus_out[5] dbus_out[4] dbus_out[3] dbus_out[2] dbus_out[1] dbus_out[0] net130[11] net130[10] net130[9] net130[8]
+ net130[7] net130[6] net130[5] net130[4] net130[3] net130[2] net130[1] net130[0] net123[11] net123[10] net123[9] net123[8] net123[7]
+ net123[6] net123[5] net123[4] net123[3] net123[2] net123[1] net123[0] proj_ibias_ena[1] proj_ibias_ena[0] vss3v3 vss3v3 vss3v3 vdd3v3
+ vss3v3 net126[3] net126[2] net126[1] net126[0] net230[23] net230[22] net230[21] net230[20] net230[19] net230[18] net230[17] net230[16]
+ net230[15] net230[14] net230[13] net230[12] net230[11] net230[10] net230[9] net230[8] net230[7] net230[6] net230[5] net230[4] net230[3]
+ net230[2] net230[1] net230[0] net129[11] net129[10] net129[9] net129[8] net129[7] net129[6] net129[5] net129[4] net129[3] net129[2]
+ net129[1] net129[0] net127[1] net127[0] proj_sel[4] proj_sel[3] proj_sel[2] proj_sel[1] proj_sel[0] user_project_control
x37[1] vdd3v3 vss3v3 vdd5v0 ibias1[1] vss5v0 net134[1] idac2_source analog_pswitch_small
x37[0] vdd3v3 vss3v3 vdd5v0 ibias1[0] vss5v0 net134[0] idac1_source analog_pswitch_small
x84 vdd3v3 vss3v3 vdd5v0 vbias1 vss5v0 net135 voltgen_vout analog_switch_small
x38[3] vdd3v3 vss3v3 vdd5v0 ana1[3] vss5v0 net133[3] analog[3] analog_switch_med
x38[2] vdd3v3 vss3v3 vdd5v0 ana1[2] vss5v0 net133[2] analog[2] analog_switch_med
x38[1] vdd3v3 vss3v3 vdd5v0 ana1[1] vss5v0 net133[1] analog[1] analog_switch_med
x38[0] vdd3v3 vss3v3 vdd5v0 ana1[0] vss5v0 net133[0] analog[0] analog_switch_med
x85 net132 vdd3v3 vss3v3 net232 power_stage3v3
x86 net131 vdd5v0 vss5v0 vss3v3 vdd3v3 net233 power_stage
x87 clk_out proj_dig_ena proj_ena proj_3v3_ena proj_5v0_ena net132 net131 net237 net234 net235 net135 reset proj_vbias_ena vdd3v3
+ vss3v3 analog_ena[3] analog_ena[2] analog_ena[1] analog_ena[0] dbus_out[23] dbus_out[22] dbus_out[21] dbus_out[20] dbus_out[19]
+ dbus_out[18] dbus_out[17] dbus_out[16] dbus_out[15] dbus_out[14] dbus_out[13] dbus_out[12] dbus_out[11] dbus_out[10] dbus_out[9] dbus_out[8]
+ dbus_out[7] dbus_out[6] dbus_out[5] dbus_out[4] dbus_out[3] dbus_out[2] dbus_out[1] dbus_out[0] dbus_in_right[11] dbus_in_right[10]
+ dbus_in_right[9] dbus_in_right[8] dbus_in_right[7] dbus_in_right[6] dbus_in_right[5] dbus_in_right[4] dbus_in_right[3] dbus_in_right[2]
+ dbus_in_right[1] dbus_in_right[0] net130[11] net130[10] net130[9] net130[8] net130[7] net130[6] net130[5] net130[4] net130[3] net130[2] net130[1]
+ net130[0] proj_ibias_ena[1] proj_ibias_ena[0] vss3v3 vss3v3 vss3v3 vss3v3 vdd3v3 net133[3] net133[2] net133[1] net133[0] net236[23]
+ net236[22] net236[21] net236[20] net236[19] net236[18] net236[17] net236[16] net236[15] net236[14] net236[13] net236[12] net236[11]
+ net236[10] net236[9] net236[8] net236[7] net236[6] net236[5] net236[4] net236[3] net236[2] net236[1] net236[0] net136[11] net136[10]
+ net136[9] net136[8] net136[7] net136[6] net136[5] net136[4] net136[3] net136[2] net136[1] net136[0] net134[1] net134[0] proj_sel[4]
+ proj_sel[3] proj_sel[2] proj_sel[1] proj_sel[0] user_project_control
x88 s1_an[0] s1_an[1] net232 vss5v0 net233 vss3v3 ana1[3] ana1[2] ana1[1] ana1[0] vbias1 ibias1[0] ibias1[1] net136[11] net136[10]
+ net136[9] net136[8] net136[7] net136[6] net136[5] net136[4] net136[3] net136[2] net136[1] net136[0] net236[23] net236[22] net236[21]
+ net236[20] net236[19] net236[18] net236[17] net236[16] net236[15] net236[14] net236[13] net236[12] net236[11] net236[10] net236[9] net236[8]
+ net236[7] net236[6] net236[5] net236[4] net236[3] net236[2] net236[1] net236[0] net235 net234 net237 slot1_wrapper
x89 s2_an[0] s2_an[1] vss5v0_slot2 net226 vss5v0 net227 vss3v3 ana2[3] ana2[2] ana2[1] ana2[0] vbias2 ibias2[0] ibias2[1]
+ net129[11] net129[10] net129[9] net129[8] net129[7] net129[6] net129[5] net129[4] net129[3] net129[2] net129[1] net129[0] net230[23]
+ net230[22] net230[21] net230[20] net230[19] net230[18] net230[17] net230[16] net230[15] net230[14] net230[13] net230[12] net230[11]
+ net230[10] net230[9] net230[8] net230[7] net230[6] net230[5] net230[4] net230[3] net230[2] net230[1] net230[0] net229 net228 net231
+ slot2_wrapper
x90 s3_an[0] s3_an[1] net220 vss5v0 net221 vss3v3 ana3[3] ana3[2] ana3[1] ana3[0] vbias3 ibias3[0] ibias3[1] net122[11] net122[10]
+ net122[9] net122[8] net122[7] net122[6] net122[5] net122[4] net122[3] net122[2] net122[1] net122[0] net224[23] net224[22] net224[21]
+ net224[20] net224[19] net224[18] net224[17] net224[16] net224[15] net224[14] net224[13] net224[12] net224[11] net224[10] net224[9] net224[8]
+ net224[7] net224[6] net224[5] net224[4] net224[3] net224[2] net224[1] net224[0] net223 net222 net225 slot3_wrapper
x91 s4_an[0] s4_an[1] net214 vss5v0 net215 vss3v3 ana4[3] ana4[2] ana4[1] ana4[0] vbias4 ibias4[0] ibias4[1] net115[11] net115[10]
+ net115[9] net115[8] net115[7] net115[6] net115[5] net115[4] net115[3] net115[2] net115[1] net115[0] net218[23] net218[22] net218[21]
+ net218[20] net218[19] net218[18] net218[17] net218[16] net218[15] net218[14] net218[13] net218[12] net218[11] net218[10] net218[9] net218[8]
+ net218[7] net218[6] net218[5] net218[4] net218[3] net218[2] net218[1] net218[0] net217 net216 net219 slot4_wrapper
x92 s5_an[0] s5_an[1] net208 vss5v0 net209 vss3v3 ana5[3] ana5[2] ana5[1] ana5[0] vbias5 ibias5[0] ibias5[1] net108[11] net108[10]
+ net108[9] net108[8] net108[7] net108[6] net108[5] net108[4] net108[3] net108[2] net108[1] net108[0] net212[23] net212[22] net212[21]
+ net212[20] net212[19] net212[18] net212[17] net212[16] net212[15] net212[14] net212[13] net212[12] net212[11] net212[10] net212[9] net212[8]
+ net212[7] net212[6] net212[5] net212[4] net212[3] net212[2] net212[1] net212[0] net211 net210 net213 slot5_wrapper
x93 s6_an[0] s6_an[1] net202 vss5v0 net203 vss3v3 ana6[3] ana6[2] ana6[1] ana6[0] vbias6 ibias6[0] ibias6[1] net101[11] net101[10]
+ net101[9] net101[8] net101[7] net101[6] net101[5] net101[4] net101[3] net101[2] net101[1] net101[0] net206[23] net206[22] net206[21]
+ net206[20] net206[19] net206[18] net206[17] net206[16] net206[15] net206[14] net206[13] net206[12] net206[11] net206[10] net206[9] net206[8]
+ net206[7] net206[6] net206[5] net206[4] net206[3] net206[2] net206[1] net206[0] net205 net204 net207 slot6_wrapper
x94 s7_an[0] s7_an[1] net196 vss5v0 net197 vss3v3 ana7[3] ana7[2] ana7[1] ana7[0] vbias7 ibias7[0] ibias7[1] net94[11] net94[10]
+ net94[9] net94[8] net94[7] net94[6] net94[5] net94[4] net94[3] net94[2] net94[1] net94[0] net200[23] net200[22] net200[21] net200[20]
+ net200[19] net200[18] net200[17] net200[16] net200[15] net200[14] net200[13] net200[12] net200[11] net200[10] net200[9] net200[8] net200[7]
+ net200[6] net200[5] net200[4] net200[3] net200[2] net200[1] net200[0] net199 net198 net201 slot7_wrapper
x95 vss5v0_slot8 s8_an[0] net190 vss5v0 net191 vss3v3 ana8[3] ana8[2] ana8[1] ana8[0] vbias8 ibias8[0] ibias8[1] net87[11]
+ net87[10] net87[9] net87[8] net87[7] net87[6] net87[5] net87[4] net87[3] net87[2] net87[1] net87[0] net194[23] net194[22] net194[21]
+ net194[20] net194[19] net194[18] net194[17] net194[16] net194[15] net194[14] net194[13] net194[12] net194[11] net194[10] net194[9] net194[8]
+ net194[7] net194[6] net194[5] net194[4] net194[3] net194[2] net194[1] net194[0] net193 net192 net195 slot8_wrapper
x96 s9_an[0] s9_an[1] s9_an[2] net75 vss5v0 net137 vss3v3 ana9[3] ana9[2] ana9[1] ana9[0] vbias9 ibias9[0] ibias9[1] net80[11]
+ net80[10] net80[9] net80[8] net80[7] net80[6] net80[5] net80[4] net80[3] net80[2] net80[1] net80[0] net188[23] net188[22] net188[21]
+ net188[20] net188[19] net188[18] net188[17] net188[16] net188[15] net188[14] net188[13] net188[12] net188[11] net188[10] net188[9] net188[8]
+ net188[7] net188[6] net188[5] net188[4] net188[3] net188[2] net188[1] net188[0] net187 net138 net189 slot9_wrapper
x100 vdd3v3 vss3v3 vdd5v0 analog[2] vss5v0 project_zero idac2_source analog_pswitch_small
x99 vdd3v3 vss3v3 vdd5v0 analog[0] vss5v0 project_zero voltgen_vout analog_switch_small
R1 vss3v3 vss5v0 0 m=1
x101 vdd3v3 vss3v3 vdd5v0 voltgen_value[2] voltgen_value[1] voltgen_value[0] vbg vss5v0 net4 voltgen_vout net3 voltgen_ena[0] net1
+ voltgen_ena[2] voltgen_ena[1] voltgen_high vgen_ena2 gf180mcu_ocd_ip__voltgen
x102 vdd5v0 voltgen_vout net1 vss5v0 net2 vgen_ena2 gf180mcu_ocd_ip__classab_buffer
x21 vddd vss3v3 mask_rev[31] mask_rev[30] mask_rev[29] mask_rev[28] mask_rev[27] mask_rev[26] mask_rev[25] mask_rev[24]
+ mask_rev[23] mask_rev[22] mask_rev[21] mask_rev[20] mask_rev[19] mask_rev[18] mask_rev[17] mask_rev[16] mask_rev[15] mask_rev[14] mask_rev[13]
+ mask_rev[12] mask_rev[11] mask_rev[10] mask_rev[9] mask_rev[8] mask_rev[7] mask_rev[6] mask_rev[5] mask_rev[4] mask_rev[3] mask_rev[2]
+ mask_rev[1] mask_rev[0] user_id_programming
XR3 CSB_one CSB_pullup rm2 r_width=0.38e-6 r_length=0.12e-6 m=1
XR2 CSB_zero CSB_pulldown rm2 r_width=0.38e-6 r_length=0.12e-6 m=1
XR4 SCK_zero SCK_pulldown rm2 r_width=0.38e-6 r_length=0.12e-6 m=1
XR5 SCK_zero SCK_pullup rm2 r_width=0.38e-6 r_length=0.12e-6 m=1
XR6 SDI_zero SDI_pulldown rm2 r_width=0.38e-6 r_length=0.12e-6 m=1
XR7 SDI_zero SDI_pullup rm2 r_width=0.38e-6 r_length=0.12e-6 m=1
XR8 clk_zero clk_pulldown rm2 r_width=0.38e-6 r_length=0.12e-6 m=1
XR9 clk_zero clk_pullup rm2 r_width=0.38e-6 r_length=0.12e-6 m=1
XR10 SDO_zero SDO_pulldown rm2 r_width=0.38e-6 r_length=0.12e-6 m=1
XR11 SDO_zero SDO_pullup rm2 r_width=0.38e-6 r_length=0.12e-6 m=1
XR12 SDO_zero SDO_slew rm2 r_width=0.38e-6 r_length=0.12e-6 m=1
XR13 SDO_zero SDO_schmitt rm2 r_width=0.38e-6 r_length=0.12e-6 m=1
XR14 SDO_zero SDO_ie rm2 r_width=0.38e-6 r_length=0.12e-6 m=1
* noconn vss5v0_slot12_13
* noconn vss5v0_slot14_15
* noconn vss3v3_slot4_5
* noconn vss3v3_slot6_7
.ends

* expanding   symbol:  gf180mcu_ocd_ip__biasgen.sym # of pins=24
** sym_path: /home/tim/gits/gf180mcu_ocd_chipalooza/dependencies/gf180mcu_ocd_ip__biasgen/xschem/gf180mcu_ocd_ip__biasgen.sym
** sch_path: /home/tim/gits/gf180mcu_ocd_chipalooza/dependencies/gf180mcu_ocd_ip__biasgen/xschem/gf180mcu_ocd_ip__biasgen.sch
.subckt gf180mcu_ocd_ip__biasgen ena avdd avss ref_in dvdd vbg ref_sel_vbg dvss bandgap_sink2[1] bandgap_sink2[0]
+ voltgen_source[4] voltgen_source[3] voltgen_source[2] voltgen_source[1] voltgen_source[0] bandgap_sink2_ibias voltgen_sink1[2] voltgen_sink1[1]
+ voltgen_sink1[0] voltgen_source_ibias idac1_source[4] idac1_source[3] idac1_source[2] idac1_source[1] idac1_source[0] voltgen_sink1_ibias
+ idac1_source_ibias idac2_source_ibias idac2_source[4] idac2_source[3] idac2_source[2] idac2_source[1] idac2_source[0] ref_sel_coarse ref_sel_fine
+ bandgap_sink1[2] bandgap_sink1[1] bandgap_sink1[0] bandgap_sink1_ibias voltgen_sink2[2] voltgen_sink2[1] voltgen_sink2[0] voltgen_sink2_ibias
*.PININFO avdd:B avss:B dvdd:B dvss:B ena:I ref_in:I vbg:I ref_sel_vbg:I bandgap_sink1[2:0]:I voltgen_sink1[2:0]:I
*+ voltgen_sink2[2:0]:I bandgap_sink1_ibias:B voltgen_sink1_ibias:B voltgen_sink2_ibias:B ref_sel_fine:I ref_sel_coarse:I voltgen_source_ibias:B
*+ voltgen_source[4:0]:I bandgap_sink2[1:0]:I bandgap_sink2_ibias:B idac1_source_ibias:B idac1_source[4:0]:I idac2_source_ibias:B idac2_source[4:0]:I
x1 avdd ena vbg net1 avss dvdd dvss ref_sel_vbg ref_in dvss nbias pcasc pbias net2 dvss ncasc ref_sel_fine ref_sel_coarse avdd
+ bias_generator_fe
* noconn #net1
* noconn #net2
x13 dvdd dvss avdd pcasc pbias voltgen_source[4] voltgen_source[3] voltgen_source[2] voltgen_source[1] voltgen_source[0]
+ voltgen_source_ibias avss avdd avdd bias_generator_be0p
x8[4] net4 avss ncasc nbias avss avss avss bias_nstack
x8[3] net4 avss ncasc nbias avss avss avss bias_nstack
x8[2] net4 avss ncasc nbias avss avss avss bias_nstack
x8[1] net4 avss ncasc nbias avss avss avss bias_nstack
x8[0] net4 avss ncasc nbias avss avss avss bias_nstack
x9[4] avdd pbias pcasc avdd net3 avdd avdd bias_pstack
x9[3] avdd pbias pcasc avdd net3 avdd avdd bias_pstack
x9[2] avdd pbias pcasc avdd net3 avdd avdd bias_pstack
x9[1] avdd pbias pcasc avdd net3 avdd avdd bias_pstack
x9[0] avdd pbias pcasc avdd net3 avdd avdd bias_pstack
* noconn #net4
* noconn #net3
x8 dvdd dvss avdd nbias avss bandgap_sink1[2] bandgap_sink1[1] bandgap_sink1[0] bandgap_sink1_ibias ncasc avss avss
+ bias_generator_ben1um
x3 dvdd dvss avdd nbias avss voltgen_sink1[2] voltgen_sink1[1] voltgen_sink1[0] voltgen_sink1_ibias ncasc avss avss
+ bias_generator_ben1um
x4 dvdd dvss avdd nbias avss voltgen_sink2[2] voltgen_sink2[1] voltgen_sink2[0] voltgen_sink2_ibias ncasc avss avss
+ bias_generator_ben1um
x2 dvdd dvss avdd nbias avss bandgap_sink2[1] bandgap_sink2[0] bandgap_sink2_ibias ncasc avss avss bias_generator_ben250nm
x5 dvdd dvss avdd pcasc pbias idac1_source[4] idac1_source[3] idac1_source[2] idac1_source[1] idac1_source[0] idac1_source_ibias
+ avss avdd avdd bias_generator_be0p
x6 dvdd dvss avdd pcasc pbias idac2_source[4] idac2_source[3] idac2_source[2] idac2_source[1] idac2_source[0] idac2_source_ibias
+ avss avdd avdd bias_generator_be0p
.ends

* expanding   symbol:  gf180mcu_ocd_ip__bandgap.sym # of pins=7
** sym_path: /home/tim/gits/gf180mcu_ocd_chipalooza/dependencies/gf180mcu_ocd_ip__biasgen/xschem/gf180mcu_ocd_ip__bandgap.sym
** sch_path: /home/tim/gits/gf180mcu_ocd_chipalooza/dependencies/gf180mcu_ocd_ip__biasgen/xschem/gf180mcu_ocd_ip__bandgap.sch
.subckt gf180mcu_ocd_ip__bandgap vbg ibias1_250n trim[15] trim[14] trim[13] trim[12] trim[11] trim[10] trim[9] trim[8] trim[7]
+ trim[6] trim[5] trim[4] trim[3] trim[2] trim[1] trim[0] dvss dvdd ena ibias2_1u
*.PININFO trim[15:0]:I ena:I vbg:O ibias2_1u:B ibias1_250n:B dvdd:B dvss:B
x1 vbg_unbuf ibias1_250n trim[15] trim[14] trim[13] trim[12] trim[11] trim[10] trim[9] trim[8] trim[7] trim[6] trim[5] trim[4]
+ trim[3] trim[2] trim[1] trim[0] dvss dvdd ena net1 bandgap_unbuffered
x3 dvdd vbg vbg_unbuf dvss ibias2_1u net1 gf180mcu_ocd_ip__classab_buffer
.ends

* expanding   symbol:  analog_pswitch_small.sym # of pins=7
** sym_path: /home/tim/gits/gf180mcu_ocd_chipalooza/dependencies/gf180mcu_ocd_ip__analog_switches/xschem/analog_pswitch_small.sym
** sch_path: /home/tim/gits/gf180mcu_ocd_chipalooza/dependencies/gf180mcu_ocd_ip__analog_switches/xschem/analog_pswitch_small.sch
.subckt analog_pswitch_small dvdd dvss avdd in avss enable out
*.PININFO in:B out:B enable:I dvdd:B dvss:B avdd:B avss:B
x5 net2 net1 net4 net3 avdd avss sw_lvl_shift
* noconn #net4
x1[1] dvss dvdd gf180mcu_as_sc_mcu7t3v3__tap_2
x1[0] dvss dvdd gf180mcu_as_sc_mcu7t3v3__tap_2
XM1 out net3 in avdd pfet_05v0 L=0.50u W=6.0u nf=1 ad='int((nf+1)/2) * W/nf * 0.18u' as='int((nf+2)/2) * W/nf * 0.18u' pd='2*int((nf+1)/2) * (W/nf + 0.18u)'
+ ps='2*int((nf+2)/2) * (W/nf + 0.18u)' nrd='0.18u / W' nrs='0.18u / W' sa=0 sb=0 sd=0 m=4 par=4
x6 dvdd dvdd dvss dvss net1 enable gf180mcu_as_sc_mcu7t3v3__inv_4
x7 dvdd dvdd dvss dvss net2 net1 gf180mcu_as_sc_mcu7t3v3__inv_4
x2 dvdd dvdd dvss dvss enable gf180mcu_as_sc_mcu7t3v3__diode_2
x3 dvdd dvdd dvss dvss gf180mcu_as_sc_mcu7t3v3__fillcap_4
.ends

* expanding   symbol:  analog_switch_small.sym # of pins=7
** sym_path: /home/tim/gits/gf180mcu_ocd_chipalooza/dependencies/gf180mcu_ocd_ip__analog_switches/xschem/analog_switch_small.sym
** sch_path: /home/tim/gits/gf180mcu_ocd_chipalooza/dependencies/gf180mcu_ocd_ip__analog_switches/xschem/analog_switch_small.sch
.subckt analog_switch_small dvdd dvss avdd in avss enable out
*.PININFO in:B out:B enable:I dvdd:B dvss:B avdd:B avss:B
x5 net4 net2 net3 net1 avdd avss sw_lvl_shift
x1[1] avss avdd gf180mcu_as_sc_mcu7t3v3__tap_2
x1[0] avss avdd gf180mcu_as_sc_mcu7t3v3__tap_2
XM3 in net3 out avss nfet_05v0 L=0.60u W=6.0u nf=1 ad='int((nf+1)/2) * W/nf * 0.18u' as='int((nf+2)/2) * W/nf * 0.18u' pd='2*int((nf+1)/2) * (W/nf + 0.18u)'
+ ps='2*int((nf+2)/2) * (W/nf + 0.18u)' nrd='0.18u / W' nrs='0.18u / W' sa=0 sb=0 sd=0 m=4 par=4
XM4 out net1 in avdd pfet_05v0 L=0.50u W=6.0u nf=1 ad='int((nf+1)/2) * W/nf * 0.18u' as='int((nf+2)/2) * W/nf * 0.18u' pd='2*int((nf+1)/2) * (W/nf + 0.18u)'
+ ps='2*int((nf+2)/2) * (W/nf + 0.18u)' nrd='0.18u / W' nrs='0.18u / W' sa=0 sb=0 sd=0 m=4 par=4
x1 dvdd dvdd dvss dvss net2 enable gf180mcu_as_sc_mcu7t3v3__inv_4
x7 dvdd dvdd dvss dvss enable gf180mcu_as_sc_mcu7t3v3__diode_2
x8 dvdd dvdd dvss dvss gf180mcu_as_sc_mcu7t3v3__fillcap_4
x9 dvdd dvdd dvss dvss net4 net2 gf180mcu_as_sc_mcu7t3v3__inv_4
.ends

* expanding   symbol:  analog_switch_med.sym # of pins=7
** sym_path: /home/tim/gits/gf180mcu_ocd_chipalooza/dependencies/gf180mcu_ocd_ip__analog_switches/xschem/analog_switch_med.sym
** sch_path: /home/tim/gits/gf180mcu_ocd_chipalooza/dependencies/gf180mcu_ocd_ip__analog_switches/xschem/analog_switch_med.sch
.subckt analog_switch_med dvdd dvss avdd in avss enable out
*.PININFO in:B out:B enable:I dvdd:B dvss:B avdd:B avss:B
x1 net2 net4 net3 avdd avss net1 gate_drive_med
x1[1] dvss dvdd gf180mcu_as_sc_mcu7t3v3__tap_2
x1[0] dvss dvdd gf180mcu_as_sc_mcu7t3v3__tap_2
XM3 in net3 out avss nfet_05v0 L=0.60u W=12.0u nf=1 ad='int((nf+1)/2) * W/nf * 0.18u' as='int((nf+2)/2) * W/nf * 0.18u' pd='2*int((nf+1)/2) * (W/nf + 0.18u)'
+ ps='2*int((nf+2)/2) * (W/nf + 0.18u)' nrd='0.18u / W' nrs='0.18u / W' sa=0 sb=0 sd=0 m=39 par=39
x5 dvdd dvdd dvss dvss net2 enable gf180mcu_as_sc_mcu7t3v3__inv_4
x6 dvdd dvdd dvss dvss enable gf180mcu_as_sc_mcu7t3v3__diode_2
x7[1] dvdd dvdd dvss dvss gf180mcu_as_sc_mcu7t3v3__fillcap_4
x7[0] dvdd dvdd dvss dvss gf180mcu_as_sc_mcu7t3v3__fillcap_4
x2 dvdd dvdd dvss dvss net4 net2 gf180mcu_as_sc_mcu7t3v3__inv_4
XM2 out net1 in avdd pfet_05v0 L=0.50u W=12.0u nf=1 ad='int((nf+1)/2) * W/nf * 0.18u' as='int((nf+2)/2) * W/nf * 0.18u' pd='2*int((nf+1)/2) * (W/nf + 0.18u)'
+ ps='2*int((nf+2)/2) * (W/nf + 0.18u)' nrd='0.18u / W' nrs='0.18u / W' sa=0 sb=0 sd=0 m=39 par=39
.ends

* expanding   symbol:  power_stage3v3.sym # of pins=4
** sym_path: /home/tim/gits/gf180mcu_ocd_chipalooza/dependencies/gf180mcu_ocd_ip__analog_switches/xschem/power_stage3v3.sym
** sch_path: /home/tim/gits/gf180mcu_ocd_chipalooza/dependencies/gf180mcu_ocd_ip__analog_switches/xschem/power_stage3v3.sch
.subckt power_stage3v3 enable DVDD_IN DVSS DVDD_OUT
*.PININFO enable:I DVDD_IN:I DVSS:I DVDD_OUT:O
XM2 DVDD_OUT P_DRIVE DVDD_IN DVDD_IN pfet_03v3 L=0.28u W=10.0u nf=1 ad='int((nf+1)/2) * W/nf * 0.18u' as='int((nf+2)/2) * W/nf * 0.18u'
+ pd='2*int((nf+1)/2) * (W/nf + 0.18u)' ps='2*int((nf+2)/2) * (W/nf + 0.18u)' nrd='0.18u / W' nrs='0.18u / W' sa=0 sb=0 sd=0 m=520 par=520
x1 DVDD_IN DVSS P_DRIVE enable gate_drive_3v3
.ends

* expanding   symbol:  power_stage.sym # of pins=6
** sym_path: /home/tim/gits/gf180mcu_ocd_chipalooza/dependencies/gf180mcu_ocd_ip__analog_switches/xschem/power_stage.sym
** sch_path: /home/tim/gits/gf180mcu_ocd_chipalooza/dependencies/gf180mcu_ocd_ip__analog_switches/xschem/power_stage.sch
.subckt power_stage enable IOVDD_IN IOVSS DVSS DVDD IOVDD_OUT
*.PININFO enable:I IOVDD_IN:I DVSS:I DVDD:I IOVSS:I IOVDD_OUT:O
x2 net2 net1 P_DRIVE IOVDD_IN IOVSS gate_drive_large
x1 DVDD VNW VPW DVSS net1 enable gf180mcu_as_sc_mcu7t3v3__inv_4
x3 DVDD VNW VPW DVSS net2 net1 gf180mcu_as_sc_mcu7t3v3__inv_4
x4[1] DVDD VNW VPW DVSS gf180mcu_as_sc_mcu7t3v3__fillcap_4
x4[0] DVDD VNW VPW DVSS gf180mcu_as_sc_mcu7t3v3__fillcap_4
x9 DVDD VNW VPW DVSS enable gf180mcu_as_sc_mcu7t3v3__diode_2
XM1 IOVDD_OUT P_DRIVE IOVDD_IN IOVDD_IN pfet_05v0 L=0.50u W=10.0u nf=1 ad='int((nf+1)/2) * W/nf * 0.18u' as='int((nf+2)/2) * W/nf * 0.18u'
+ pd='2*int((nf+1)/2) * (W/nf + 0.18u)' ps='2*int((nf+2)/2) * (W/nf + 0.18u)' nrd='0.18u / W' nrs='0.18u / W' sa=0 sb=0 sd=0 m=720 par=720
x4 DVSS DVDD gf180mcu_as_sc_mcu7t3v3__tap_2
.ends

* expanding   symbol:  gf180mcu_ocd_ip__por.sym # of pins=6
** sym_path: /home/tim/gits/gf180mcu_ocd_chipalooza/dependencies/gf180mcu_ocd_ip__por/xschem/gf180mcu_ocd_ip__por.sym
** sch_path: /home/tim/gits/gf180mcu_ocd_chipalooza/dependencies/gf180mcu_ocd_ip__por/xschem/gf180mcu_ocd_ip__por.sch
.subckt gf180mcu_ocd_ip__por vdd3v3 ena por_unbuf vss porb por
*.PININFO ena:I vdd3v3:B vss:B por_unbuf:O porb:O por:O
x1 vdd3v3 vpb vref vfb ena vss net9 por_amp
x2 vdd3v3 vcap por_unbuf vss por_3v3_schmitt_inv
XM1 nb1 nb1 net2 vss nfet_03v3 L=0.28u W=6u nf=12 ad='int((nf+1)/2) * W/nf * 0.18u' as='int((nf+2)/2) * W/nf * 0.18u' pd='2*int((nf+1)/2) * (W/nf + 0.18u)'
+ ps='2*int((nf+2)/2) * (W/nf + 0.18u)' nrd='0.18u / W' nrs='0.18u / W' sa=0 sb=0 sd=0 m=1 par=1
XM2 net1 vpb net7 vdd3v3 pfet_03v3 L=0.28u W=6.0u nf=12 ad='int((nf+1)/2) * W/nf * 0.18u' as='int((nf+2)/2) * W/nf * 0.18u' pd='2*int((nf+1)/2) * (W/nf + 0.18u)'
+ ps='2*int((nf+2)/2) * (W/nf + 0.18u)' nrd='0.18u / W' nrs='0.18u / W' sa=0 sb=0 sd=0 m=1 par=1
XR1 vss vfb vss ppolyf_u_1k r_width=1e-6 r_length=2500e-6 m=1
XM3 vfb vfb net1 vdd3v3 pfet_03v3 L=0.28u W=6u nf=12 ad='int((nf+1)/2) * W/nf * 0.18u' as='int((nf+2)/2) * W/nf * 0.18u' pd='2*int((nf+1)/2) * (W/nf + 0.18u)'
+ ps='2*int((nf+2)/2) * (W/nf + 0.18u)' nrd='0.18u / W' nrs='0.18u / W' sa=0 sb=0 sd=0 m=1 par=1
XM4 p1 vpb net6 vdd3v3 pfet_03v3 L=0.28u W=0.5u nf=1 ad='int((nf+1)/2) * W/nf * 0.18u' as='int((nf+2)/2) * W/nf * 0.18u' pd='2*int((nf+1)/2) * (W/nf + 0.18u)'
+ ps='2*int((nf+2)/2) * (W/nf + 0.18u)' nrd='0.18u / W' nrs='0.18u / W' sa=0 sb=0 sd=0 m=1 par=1
XM5 nb1 vfb p1 vdd3v3 pfet_03v3 L=0.28u W=0.5u nf=1 ad='int((nf+1)/2) * W/nf * 0.18u' as='int((nf+2)/2) * W/nf * 0.18u' pd='2*int((nf+1)/2) * (W/nf + 0.18u)'
+ ps='2*int((nf+2)/2) * (W/nf + 0.18u)' nrd='0.18u / W' nrs='0.18u / W' sa=0 sb=0 sd=0 m=1 par=1
XM6 net2 net2 vss vss nfet_03v3 L=0.28u W=6u nf=12 ad='int((nf+1)/2) * W/nf * 0.18u' as='int((nf+2)/2) * W/nf * 0.18u' pd='2*int((nf+1)/2) * (W/nf + 0.18u)'
+ ps='2*int((nf+2)/2) * (W/nf + 0.18u)' nrd='0.18u / W' nrs='0.18u / W' sa=0 sb=0 sd=0 m=1 par=1
XM7 pb1 nb1 n1 vss nfet_03v3 L=0.28u W=0.5u nf=1 ad='int((nf+1)/2) * W/nf * 0.18u' as='int((nf+2)/2) * W/nf * 0.18u' pd='2*int((nf+1)/2) * (W/nf + 0.18u)'
+ ps='2*int((nf+2)/2) * (W/nf + 0.18u)' nrd='0.18u / W' nrs='0.18u / W' sa=0 sb=0 sd=0 m=1 par=1
XM8 n1 net2 vss vss nfet_03v3 L=0.28u W=0.5u nf=1 ad='int((nf+1)/2) * W/nf * 0.18u' as='int((nf+2)/2) * W/nf * 0.18u' pd='2*int((nf+1)/2) * (W/nf + 0.18u)'
+ ps='2*int((nf+2)/2) * (W/nf + 0.18u)' nrd='0.18u / W' nrs='0.18u / W' sa=0 sb=0 sd=0 m=1 par=1
XM9 pb1 pb1 net3 vdd3v3 pfet_03v3 L=0.28u W=4u nf=8 ad='int((nf+1)/2) * W/nf * 0.18u' as='int((nf+2)/2) * W/nf * 0.18u' pd='2*int((nf+1)/2) * (W/nf + 0.18u)'
+ ps='2*int((nf+2)/2) * (W/nf + 0.18u)' nrd='0.18u / W' nrs='0.18u / W' sa=0 sb=0 sd=0 m=1 par=1
XM10 net3 net3 net5 vdd3v3 pfet_03v3 L=0.28u W=4u nf=8 ad='int((nf+1)/2) * W/nf * 0.18u' as='int((nf+2)/2) * W/nf * 0.18u' pd='2*int((nf+1)/2) * (W/nf + 0.18u)'
+ ps='2*int((nf+2)/2) * (W/nf + 0.18u)' nrd='0.18u / W' nrs='0.18u / W' sa=0 sb=0 sd=0 m=1 par=1
XM11 p2 net3 net4 vdd3v3 pfet_03v3 L=0.28u W=0.5u nf=1 ad='int((nf+1)/2) * W/nf * 0.18u' as='int((nf+2)/2) * W/nf * 0.18u' pd='2*int((nf+1)/2) * (W/nf + 0.18u)'
+ ps='2*int((nf+2)/2) * (W/nf + 0.18u)' nrd='0.18u / W' nrs='0.18u / W' sa=0 sb=0 sd=0 m=1 par=1
XM12 vcap pb1 p2 vdd3v3 pfet_03v3 L=0.28u W=0.5u nf=1 ad='int((nf+1)/2) * W/nf * 0.18u' as='int((nf+2)/2) * W/nf * 0.18u' pd='2*int((nf+1)/2) * (W/nf + 0.18u)'
+ ps='2*int((nf+2)/2) * (W/nf + 0.18u)' nrd='0.18u / W' nrs='0.18u / W' sa=0 sb=0 sd=0 m=1 par=1
XC1 vcap vss cap_mim_2f0_m4m5_noshield c_width=10e-6 c_length=10e-6 m=36
D1 vss ena diode_nd2ps_03v3 area='0.45u * 0.45u ' pj='2*0.45u + 2*0.45u ' m=1
Vmeas vdd3v3 net7 0
.save i(vmeas)
Vmeas1 vdd3v3 net6 0
.save i(vmeas1)
Vmeas2 vdd3v3 net5 0
.save i(vmeas2)
Vmeas3 vdd3v3 net4 0
.save i(vmeas3)
x3[1] vdd3v3 vdd3v3 vss vss gf180mcu_as_sc_mcu7t3v3__fillcap_4
x3[0] vdd3v3 vdd3v3 vss vss gf180mcu_as_sc_mcu7t3v3__fillcap_4
x4[1] vss vdd3v3 gf180mcu_as_sc_mcu7t3v3__tap_2
x4[0] vss vdd3v3 gf180mcu_as_sc_mcu7t3v3__tap_2
x5 vdd3v3 vdd3v3 vss vss por_unbuf por gf180mcu_as_sc_mcu7t3v3__buff_12
x6 vdd3v3 vdd3v3 vss vss net8 por_unbuf gf180mcu_as_sc_mcu7t3v3__inv_4
x3 vdd3v3 vdd3v3 vss vss net8 porb gf180mcu_as_sc_mcu7t3v3__buff_12
XR2 vref vdd3v3 vss ppolyf_u_1k r_width=1e-6 r_length=2500e-6 m=1
Vmeas4 vref net10 0
.save i(vmeas4)
XM13 net9 net9 vss vss nfet_03v3 L=0.28u W=8.0u nf=8 ad='int((nf+1)/2) * W/nf * 0.18u' as='int((nf+2)/2) * W/nf * 0.18u' pd='2*int((nf+1)/2) * (W/nf + 0.18u)'
+ ps='2*int((nf+2)/2) * (W/nf + 0.18u)' nrd='0.18u / W' nrs='0.18u / W' sa=0 sb=0 sd=0 m=1 par=1
XM14 net10 net10 net9 vss nfet_03v3 L=0.28u W=8.0u nf=8 ad='int((nf+1)/2) * W/nf * 0.18u' as='int((nf+2)/2) * W/nf * 0.18u' pd='2*int((nf+1)/2) * (W/nf + 0.18u)'
+ ps='2*int((nf+2)/2) * (W/nf + 0.18u)' nrd='0.18u / W' nrs='0.18u / W' sa=0 sb=0 sd=0 m=1 par=1
XM15 vdd3v3 vdd3v3 vdd3v3 vdd3v3 pfet_03v3 L=0.28u W=0.5u nf=1 ad='int((nf+1)/2) * W/nf * 0.18u' as='int((nf+2)/2) * W/nf * 0.18u'
+ pd='2*int((nf+1)/2) * (W/nf + 0.18u)' ps='2*int((nf+2)/2) * (W/nf + 0.18u)' nrd='0.18u / W' nrs='0.18u / W' sa=0 sb=0 sd=0 m=2 par=2
XM16 vdd3v3 vdd3v3 p1 vdd3v3 pfet_03v3 L=0.28u W=0.5u nf=1 ad='int((nf+1)/2) * W/nf * 0.18u' as='int((nf+2)/2) * W/nf * 0.18u' pd='2*int((nf+1)/2) * (W/nf + 0.18u)'
+ ps='2*int((nf+2)/2) * (W/nf + 0.18u)' nrd='0.18u / W' nrs='0.18u / W' sa=0 sb=0 sd=0 m=1 par=1
XM17 vfb vdd3v3 p1 vdd3v3 pfet_03v3 L=0.28u W=0.5u nf=1 ad='int((nf+1)/2) * W/nf * 0.18u' as='int((nf+2)/2) * W/nf * 0.18u' pd='2*int((nf+1)/2) * (W/nf + 0.18u)'
+ ps='2*int((nf+2)/2) * (W/nf + 0.18u)' nrd='0.18u / W' nrs='0.18u / W' sa=0 sb=0 sd=0 m=1 par=1
XM18 vdd3v3 vdd3v3 vfb vdd3v3 pfet_03v3 L=0.28u W=0.5u nf=1 ad='int((nf+1)/2) * W/nf * 0.18u' as='int((nf+2)/2) * W/nf * 0.18u' pd='2*int((nf+1)/2) * (W/nf + 0.18u)'
+ ps='2*int((nf+2)/2) * (W/nf + 0.18u)' nrd='0.18u / W' nrs='0.18u / W' sa=0 sb=0 sd=0 m=1 par=1
XM19 vss vss vss vss nfet_03v3 L=0.28u W=0.5u nf=1 ad='int((nf+1)/2) * W/nf * 0.18u' as='int((nf+2)/2) * W/nf * 0.18u' pd='2*int((nf+1)/2) * (W/nf + 0.18u)'
+ ps='2*int((nf+2)/2) * (W/nf + 0.18u)' nrd='0.18u / W' nrs='0.18u / W' sa=0 sb=0 sd=0 m=1 par=1
XM20 n1 vss vss vss nfet_03v3 L=0.28u W=0.5u nf=1 ad='int((nf+1)/2) * W/nf * 0.18u' as='int((nf+2)/2) * W/nf * 0.18u' pd='2*int((nf+1)/2) * (W/nf + 0.18u)'
+ ps='2*int((nf+2)/2) * (W/nf + 0.18u)' nrd='0.18u / W' nrs='0.18u / W' sa=0 sb=0 sd=0 m=1 par=1
XM21 n1 vss nb1 vss nfet_03v3 L=0.28u W=0.5u nf=1 ad='int((nf+1)/2) * W/nf * 0.18u' as='int((nf+2)/2) * W/nf * 0.18u' pd='2*int((nf+1)/2) * (W/nf + 0.18u)'
+ ps='2*int((nf+2)/2) * (W/nf + 0.18u)' nrd='0.18u / W' nrs='0.18u / W' sa=0 sb=0 sd=0 m=1 par=1
XM22 nb1 vss vss vss nfet_03v3 L=0.28u W=0.5u nf=1 ad='int((nf+1)/2) * W/nf * 0.18u' as='int((nf+2)/2) * W/nf * 0.18u' pd='2*int((nf+1)/2) * (W/nf + 0.18u)'
+ ps='2*int((nf+2)/2) * (W/nf + 0.18u)' nrd='0.18u / W' nrs='0.18u / W' sa=0 sb=0 sd=0 m=1 par=1
XM23 vdd3v3 vdd3v3 p2 vdd3v3 pfet_03v3 L=0.28u W=0.5u nf=1 ad='int((nf+1)/2) * W/nf * 0.18u' as='int((nf+2)/2) * W/nf * 0.18u' pd='2*int((nf+1)/2) * (W/nf + 0.18u)'
+ ps='2*int((nf+2)/2) * (W/nf + 0.18u)' nrd='0.18u / W' nrs='0.18u / W' sa=0 sb=0 sd=0 m=1 par=1
XM24 pb1 vdd3v3 p2 vdd3v3 pfet_03v3 L=0.28u W=0.5u nf=1 ad='int((nf+1)/2) * W/nf * 0.18u' as='int((nf+2)/2) * W/nf * 0.18u' pd='2*int((nf+1)/2) * (W/nf + 0.18u)'
+ ps='2*int((nf+2)/2) * (W/nf + 0.18u)' nrd='0.18u / W' nrs='0.18u / W' sa=0 sb=0 sd=0 m=1 par=1
XM25 vdd3v3 vdd3v3 pb1 vdd3v3 pfet_03v3 L=0.28u W=0.5u nf=1 ad='int((nf+1)/2) * W/nf * 0.18u' as='int((nf+2)/2) * W/nf * 0.18u' pd='2*int((nf+1)/2) * (W/nf + 0.18u)'
+ ps='2*int((nf+2)/2) * (W/nf + 0.18u)' nrd='0.18u / W' nrs='0.18u / W' sa=0 sb=0 sd=0 m=1 par=1
XC3 vref vpb cap_mim_2f0_m4m5_noshield c_width=10e-6 c_length=10e-6 m=4
.ends

* expanding   symbol:  gf180mcu_ocd_ip__voltgen.sym # of pins=15
** sym_path: /home/tim/gits/gf180mcu_ocd_chipalooza/dependencies/gf180mcu_ocd_ip__biasgen/xschem/gf180mcu_ocd_ip__voltgen.sym
** sch_path: /home/tim/gits/gf180mcu_ocd_chipalooza/dependencies/gf180mcu_ocd_ip__biasgen/xschem/gf180mcu_ocd_ip__voltgen.sch
.subckt gf180mcu_ocd_ip__voltgen dvdd dvss vdd s[2] s[1] s[0] vbg vss ibias1u_1 vout_buf ibias1u_2 ena vout_unbuf ena1 ena2 high
+ vgen_ena2_h
*.PININFO vdd:B vss:B vbg:I vout_unbuf:O ibias1u_1:B s[2:0]:I dvdd:B dvss:B ena:I vout_buf:O ibias1u_2:B ena1:I ena2:I high:I
*+ vgen_ena2_h:O
x2 v7b vdd vref7 vout_unbuf vss v7 xgate
x3 vdd v0 v0b vss hv_inv_1
x4 v6b vdd vref6 vout_unbuf vss v6 xgate
x5 v5b vdd vref5 vout_unbuf vss v5 xgate
x6 v4b vdd vref4 vout_unbuf vss v4 xgate
x7 v3b vdd vref3 vout_unbuf vss v3 xgate
x8 v2b vdd vref2 vout_unbuf vss v2 xgate
x9 v1b vdd vref1 vout_unbuf vss v1 xgate
x10 v0b vdd vref0 vout_unbuf vss v0 xgate
x11 net2 net1 v0 vdd vss level_shift_5v
x12 dvdd dvdd dvss dvss net1 net2 gf180mcu_as_sc_mcu7t3v3__inv_2
x13 dvdd dvdd dvss dvss s2b s1b s0b net2 gf180mcu_as_sc_mcu7t3v3__nand3_2
x14 dvdd dvdd dvss dvss s0b s[0] gf180mcu_as_sc_mcu7t3v3__inv_2
x15 dvdd dvdd dvss dvss s1b s[1] gf180mcu_as_sc_mcu7t3v3__inv_2
x16 dvdd dvdd dvss dvss s2b s[2] gf180mcu_as_sc_mcu7t3v3__inv_2
x17 dvdd dvdd dvss dvss s0 s0b gf180mcu_as_sc_mcu7t3v3__inv_2
x18 dvdd dvdd dvss dvss s1 s1b gf180mcu_as_sc_mcu7t3v3__inv_2
x19 dvdd dvdd dvss dvss s2 s2b gf180mcu_as_sc_mcu7t3v3__inv_2
x20 vdd v1 v1b vss hv_inv_1
x21 net4 net3 v1 vdd vss level_shift_5v
x22 dvdd dvdd dvss dvss net3 net4 gf180mcu_as_sc_mcu7t3v3__inv_2
x23 dvdd dvdd dvss dvss s2b s1b s0 net4 gf180mcu_as_sc_mcu7t3v3__nand3_2
x24 vdd v2 v2b vss hv_inv_1
x25 net6 net5 v2 vdd vss level_shift_5v
x26 dvdd dvdd dvss dvss net5 net6 gf180mcu_as_sc_mcu7t3v3__inv_2
x27 dvdd dvdd dvss dvss s2b s1 s0b net6 gf180mcu_as_sc_mcu7t3v3__nand3_2
x28 vdd v3 v3b vss hv_inv_1
x29 net8 net7 v3 vdd vss level_shift_5v
x30 dvdd dvdd dvss dvss net7 net8 gf180mcu_as_sc_mcu7t3v3__inv_2
x31 dvdd dvdd dvss dvss s2b s1 s0 net8 gf180mcu_as_sc_mcu7t3v3__nand3_2
x32 vdd v4 v4b vss hv_inv_1
x33 net10 net9 v4 vdd vss level_shift_5v
x34 dvdd dvdd dvss dvss net9 net10 gf180mcu_as_sc_mcu7t3v3__inv_2
x35 dvdd dvdd dvss dvss s2 s1b s0b net10 gf180mcu_as_sc_mcu7t3v3__nand3_2
x36 vdd v5 v5b vss hv_inv_1
x37 net12 net11 v5 vdd vss level_shift_5v
x38 dvdd dvdd dvss dvss net11 net12 gf180mcu_as_sc_mcu7t3v3__inv_2
x39 dvdd dvdd dvss dvss s2 s1b s0 net12 gf180mcu_as_sc_mcu7t3v3__nand3_2
x40 vdd v6 v6b vss hv_inv_1
x41 net14 net13 v6 vdd vss level_shift_5v
x42 dvdd dvdd dvss dvss net13 net14 gf180mcu_as_sc_mcu7t3v3__inv_2
x43 dvdd dvdd dvss dvss s2 s1 s0b net14 gf180mcu_as_sc_mcu7t3v3__nand3_2
x44 vdd v7 v7b vss hv_inv_1
x45 net16 net15 v7 vdd vss level_shift_5v
x46 dvdd dvdd dvss dvss net15 net16 gf180mcu_as_sc_mcu7t3v3__inv_2
x47 dvdd dvdd dvss dvss s2 s1 s0 net16 gf180mcu_as_sc_mcu7t3v3__nand3_2
x1 net18 ena vgen_ena_h vdd vss level_shift_5v
x51 dvdd dvdd dvss dvss net18 ena gf180mcu_as_sc_mcu7t3v3__inv_2
x48 vdd net22 vbg net17 ibias1u_1 vss vgen_ena_h n_amp_large
x49 net19 ena1 vgen_ena1_h vdd vss level_shift_5v
x53 dvdd dvdd dvss dvss net19 ena1 gf180mcu_as_sc_mcu7t3v3__inv_2
x54 net20 ena2 vgen_ena2_h vdd vss level_shift_5v
x55 dvdd dvdd dvss dvss net20 ena2 gf180mcu_as_sc_mcu7t3v3__inv_2
x56 high_h vdd net17 vref3 vss low_h xgate
x57 low_h vdd net17 vref2 vss high_h xgate
x58 net21 high high_h vdd vss level_shift_5v
x59 dvdd dvdd dvss dvss net21 high gf180mcu_as_sc_mcu7t3v3__inv_2
x60 vdd high_h low_h vss hv_inv_1
x67 dvdd dvdd dvss dvss s[0] gf180mcu_as_sc_mcu7t3v3__diode_2
x61 dvdd dvdd dvss dvss s[1] gf180mcu_as_sc_mcu7t3v3__diode_2
x62 dvdd dvdd dvss dvss s[2] gf180mcu_as_sc_mcu7t3v3__diode_2
x63 dvdd dvdd dvss dvss high gf180mcu_as_sc_mcu7t3v3__diode_2
x64 dvdd dvdd dvss dvss ena gf180mcu_as_sc_mcu7t3v3__diode_2
x65 dvdd dvdd dvss dvss ena1 gf180mcu_as_sc_mcu7t3v3__diode_2
x66 dvdd dvdd dvss dvss ena2 gf180mcu_as_sc_mcu7t3v3__diode_2
XC1 vdd net22 cap_mim_2f0_m4m5_noshield c_width=30e-6 c_length=30e-6 m=1
XR11 vref6 vref7 vss ppolyf_u_1k r_width=1e-6 r_length=5e-6 m=1
XR1 vref5 vref6 vss ppolyf_u_1k r_width=1e-6 r_length=5e-6 m=1
XR2 vref4 vref5 vss ppolyf_u_1k r_width=1e-6 r_length=5e-6 m=1
XR3 vref3 vref4 vss ppolyf_u_1k r_width=1e-6 r_length=5e-6 m=1
XR4 vref2 vref3 vss ppolyf_u_1k r_width=1e-6 r_length=5e-6 m=1
XR5 vref1 vref2 vss ppolyf_u_1k r_width=1e-6 r_length=5e-6 m=1
XR6 vref0 vref1 vss ppolyf_u_1k r_width=1e-6 r_length=5e-6 m=1
XR7 vss vref0 vss ppolyf_u_1k r_width=1e-6 r_length=5e-6 m=1
XR8 vss vss vss ppolyf_u_1k r_width=1e-6 r_length=5e-6 m=1
XR9 vss vss vss ppolyf_u_1k r_width=1e-6 r_length=5e-6 m=1
XM2 vref7 net22 vdd vdd pfet_05v0 L=0.50u W=2.0u nf=1 ad='int((nf+1)/2) * W/nf * 0.18u' as='int((nf+2)/2) * W/nf * 0.18u' pd='2*int((nf+1)/2) * (W/nf + 0.18u)'
+ ps='2*int((nf+2)/2) * (W/nf + 0.18u)' nrd='0.18u / W' nrs='0.18u / W' sa=0 sb=0 sd=0 m=1 par=1
x50 vdd vout_buf vout_unbuf vout_buf vss ibias1u_2 vgen_ena1_h se_folded_cascode_p_5v
.ends

* expanding   symbol:  gf180mcu_ocd_ip__classab_buffer.sym # of pins=6
** sym_path: /home/tim/gits/gf180mcu_ocd_chipalooza/dependencies/gf180mcu_ocd_ip__biasgen/xschem/gf180mcu_ocd_ip__classab_buffer.sym
** sch_path: /home/tim/gits/gf180mcu_ocd_chipalooza/dependencies/gf180mcu_ocd_ip__biasgen/xschem/gf180mcu_ocd_ip__classab_buffer.sch
.subckt gf180mcu_ocd_ip__classab_buffer vdd out inp vss bias ena
*.PININFO inp:I ena:I bias:B vdd:B vss:B out:O
x1 vdd out inp out vss bias ena se_folded_cascode_np_ab
.ends

* expanding   symbol:  bias_generator_fe.sym # of pins=19
** sym_path: /home/tim/gits/gf180mcu_ocd_chipalooza/dependencies/gf180mcu_ocd_ip__biasgen/xschem/bias_generator_fe.sym
** sch_path: /home/tim/gits/gf180mcu_ocd_chipalooza/dependencies/gf180mcu_ocd_ip__biasgen/xschem/bias_generator_fe.sch
.subckt bias_generator_fe avdd ena vbg src_test0 avss dvdd ena_src_test0 ref_sel_vbg ref_in dvss nbias pcasc pbias snk_test0
+ ena_snk_test0 ncasc ref_sel_fine ref_sel_coarse shld2
*.PININFO ref_in:I avss:B ref_sel_vbg:I avdd:B ena_src_test0:I ena_snk_test0:I src_test0:B snk_test0:B vbg:I ena:I dvdd:B dvss:B
*+ pcasc:O pbias:O nbias:O ncasc:O ref_sel_fine:I shld2:B ref_sel_coarse:I
x4 net1 ena_5v0 ncasc nbias avss avss avss bias_nstack
x13[1] avdd pbias pcasc enb_test0_5v0 src_test0 shld2 avdd bias_pstack
x13[0] avdd pbias pcasc enb_test0_5v0 src_test0 shld2 avdd bias_pstack
x17[1] snk_test0 ena_test0_5v0 ncasc nbias avss avss avss bias_nstack
x17[0] snk_test0 ena_test0_5v0 ncasc nbias avss avss avss bias_nstack
x1 ref_sel_vbg net2 enb_vbg_5v0 avdd avss level_shift_5v
x11 net5 ena_snk_test0 ena_test0_5v0 avdd avss level_shift_5v
x23 ena_src_test0 net4 enb_test0_5v0 avdd avss level_shift_5v
x24 dvdd dvdd dvss dvss net3 ena gf180mcu_as_sc_mcu7t3v3__inv_2
x35 dvdd dvdd dvss dvss net2 ref_sel_vbg gf180mcu_as_sc_mcu7t3v3__inv_2
x36 net3 ena ena_5v0 avdd avss level_shift_5v
Vmeas vfb net10 0
.save i(vmeas)
x19[2] avdd pbias pcasc enb_std_5v0 vfb shld2 avdd bias_pstack
x19[1] avdd pbias pcasc enb_std_5v0 vfb shld2 avdd bias_pstack
x19[0] avdd pbias pcasc enb_std_5v0 vfb shld2 avdd bias_pstack
x5[6] dvdd dvdd dvss dvss gf180mcu_as_sc_mcu7t3v3__fillcap_4
x5[5] dvdd dvdd dvss dvss gf180mcu_as_sc_mcu7t3v3__fillcap_4
x5[4] dvdd dvdd dvss dvss gf180mcu_as_sc_mcu7t3v3__fillcap_4
x5[3] dvdd dvdd dvss dvss gf180mcu_as_sc_mcu7t3v3__fillcap_4
x5[2] dvdd dvdd dvss dvss gf180mcu_as_sc_mcu7t3v3__fillcap_4
x5[1] dvdd dvdd dvss dvss gf180mcu_as_sc_mcu7t3v3__fillcap_4
x5[0] dvdd dvdd dvss dvss gf180mcu_as_sc_mcu7t3v3__fillcap_4
x5 dvdd dvdd dvss dvss ref_sel_vbg gf180mcu_as_sc_mcu7t3v3__diode_2
x6 dvdd dvdd dvss dvss ena gf180mcu_as_sc_mcu7t3v3__diode_2
x7 dvdd dvdd dvss dvss ena_src_test0 gf180mcu_as_sc_mcu7t3v3__diode_2
x8 dvdd dvdd dvss dvss ena_snk_test0 gf180mcu_as_sc_mcu7t3v3__diode_2
x9 dvdd dvdd dvss dvss net4 ena_src_test0 gf180mcu_as_sc_mcu7t3v3__inv_2
x10 dvdd dvdd dvss dvss net5 ena_snk_test0 gf180mcu_as_sc_mcu7t3v3__inv_2
x12 net2 ref_sel_vbg ena_vbg_5v0 avdd avss level_shift_5v
x1[15] nset ena_5v0 ncasc nbias avss avss avss bias_nset
x1[14] nset ena_5v0 ncasc nbias avss avss avss bias_nset
x1[13] nset ena_5v0 ncasc nbias avss avss avss bias_nset
x1[12] nset ena_5v0 ncasc nbias avss avss avss bias_nset
x1[11] nset ena_5v0 ncasc nbias avss avss avss bias_nset
x1[10] nset ena_5v0 ncasc nbias avss avss avss bias_nset
x1[9] nset ena_5v0 ncasc nbias avss avss avss bias_nset
x1[8] nset ena_5v0 ncasc nbias avss avss avss bias_nset
x1[7] nset ena_5v0 ncasc nbias avss avss avss bias_nset
x1[6] nset ena_5v0 ncasc nbias avss avss avss bias_nset
x1[5] nset ena_5v0 ncasc nbias avss avss avss bias_nset
x1[4] nset ena_5v0 ncasc nbias avss avss avss bias_nset
x1[3] nset ena_5v0 ncasc nbias avss avss avss bias_nset
x1[2] nset ena_5v0 ncasc nbias avss avss avss bias_nset
x1[1] nset ena_5v0 ncasc nbias avss avss avss bias_nset
x1[0] nset ena_5v0 ncasc nbias avss avss avss bias_nset
x14 avdd pbias pcasc ena_vbg_5v0 net6 avdd bias_pset
Vmeas1 net7 nset 0
.save i(vmeas1)
Vmeas2 net6 net1 0
.save i(vmeas2)
x3 avdd pbias vbg vfb nbias avss ena_vbg_5v0 bias_amp_large
x2[15] avdd pbias pcasc enb_fine_5v0 vfb shld2 avdd bias_pstack
x2[14] avdd pbias pcasc enb_fine_5v0 vfb shld2 avdd bias_pstack
x2[13] avdd pbias pcasc enb_fine_5v0 vfb shld2 avdd bias_pstack
x2[12] avdd pbias pcasc enb_fine_5v0 vfb shld2 avdd bias_pstack
x2[11] avdd pbias pcasc enb_fine_5v0 vfb shld2 avdd bias_pstack
x2[10] avdd pbias pcasc enb_fine_5v0 vfb shld2 avdd bias_pstack
x2[9] avdd pbias pcasc enb_fine_5v0 vfb shld2 avdd bias_pstack
x2[8] avdd pbias pcasc enb_fine_5v0 vfb shld2 avdd bias_pstack
x2[7] avdd pbias pcasc enb_fine_5v0 vfb shld2 avdd bias_pstack
x2[6] avdd pbias pcasc enb_fine_5v0 vfb shld2 avdd bias_pstack
x2[5] avdd pbias pcasc enb_fine_5v0 vfb shld2 avdd bias_pstack
x2[4] avdd pbias pcasc enb_fine_5v0 vfb shld2 avdd bias_pstack
x2[3] avdd pbias pcasc enb_fine_5v0 vfb shld2 avdd bias_pstack
x2[2] avdd pbias pcasc enb_fine_5v0 vfb shld2 avdd bias_pstack
x2[1] avdd pbias pcasc enb_fine_5v0 vfb shld2 avdd bias_pstack
x2[0] avdd pbias pcasc enb_fine_5v0 vfb shld2 avdd bias_pstack
x15 net9 net8 enb_fine_5v0 avdd avss level_shift_5v
x16 dvdd dvdd dvss dvss net9 net8 gf180mcu_as_sc_mcu7t3v3__inv_2
x13 avdd pbias pcasc enb_coarse_5v0 vfb shld2 avdd bias_pstack
x19 net12 net11 enb_coarse_5v0 avdd avss level_shift_5v
x20 dvdd dvdd dvss dvss net12 net11 gf180mcu_as_sc_mcu7t3v3__inv_2
x21 net14 net13 enb_std_5v0 avdd avss level_shift_5v
x22 dvdd dvdd dvss dvss net14 net13 gf180mcu_as_sc_mcu7t3v3__inv_2
x30 avdd dummypbias pcasc enb_vbg_5v0 net6 pbias avdd bias_pset2
x2 dvdd dvdd dvss dvss ref_sel_coarse gf180mcu_as_sc_mcu7t3v3__diode_2
x31 dvdd dvdd dvss dvss ref_sel_fine gf180mcu_as_sc_mcu7t3v3__diode_2
x4[1] avdd dummypbias pcasc avdd vfb pbias avdd bias_pstack
x4[0] avdd dummypbias pcasc avdd vfb pbias avdd bias_pstack
x3[1] nset avss ncasc nbias avss avss avss bias_nstack
x3[0] nset avss ncasc nbias avss avss avss bias_nstack
XC2 pbias vfb cap_mim_2f0_m4m5_noshield c_width=5e-6 c_length=23e-6 m=1
XR2 avss net10 avss ppolyf_u_1k r_width=1e-6 r_length=1210e-6 m=1
x17 dvdd dvdd dvss dvss net15 ref_sel_fine ref_sel_coarse gf180mcu_as_sc_mcu7t3v3__nand2_2
x18 dvdd dvdd dvss dvss net17 ref_sel_coarse net18 gf180mcu_as_sc_mcu7t3v3__nand2_2
x25 dvdd dvdd dvss dvss net11 ref_sel_vbg net15 gf180mcu_as_sc_mcu7t3v3__nand2_2
x26 dvdd dvdd dvss dvss net8 ref_sel_vbg net16 gf180mcu_as_sc_mcu7t3v3__nand2_2
x27 dvdd dvdd dvss dvss net13 ref_sel_vbg net17 gf180mcu_as_sc_mcu7t3v3__nand2_2
x28 dvdd dvdd dvss dvss net18 ref_sel_fine gf180mcu_as_sc_mcu7t3v3__inv_2
x29 dvdd dvdd dvss dvss net16 net18 ref_sel_coarse gf180mcu_as_sc_mcu7t3v3__nor2_2
XR1 net7 ref_in avss ppolyf_u_1k r_width=1e-6 r_length=848e-6 m=1
x32[6] dvss dvdd gf180mcu_as_sc_mcu7t3v3__tap_2
x32[5] dvss dvdd gf180mcu_as_sc_mcu7t3v3__tap_2
x32[4] dvss dvdd gf180mcu_as_sc_mcu7t3v3__tap_2
x32[3] dvss dvdd gf180mcu_as_sc_mcu7t3v3__tap_2
x32[2] dvss dvdd gf180mcu_as_sc_mcu7t3v3__tap_2
x32[1] dvss dvdd gf180mcu_as_sc_mcu7t3v3__tap_2
x32[0] dvss dvdd gf180mcu_as_sc_mcu7t3v3__tap_2
.ends

* expanding   symbol:  bias_generator_be0p.sym # of pins=10
** sym_path: /home/tim/gits/gf180mcu_ocd_chipalooza/dependencies/gf180mcu_ocd_ip__biasgen/xschem/bias_generator_be0p.sym
** sch_path: /home/tim/gits/gf180mcu_ocd_chipalooza/dependencies/gf180mcu_ocd_ip__biasgen/xschem/bias_generator_be0p.sch
.subckt bias_generator_be0p dvdd dvss avdd pcasc pbias source_ena[4] source_ena[3] source_ena[2] source_ena[1] source_ena[0]
+ source_ibias avss shld2 shld3
*.PININFO avss:B avdd:B dvdd:B dvss:B pcasc:I pbias:I source_ena[4:0]:I source_ibias:B shld2:B shld3:B
x9[4] source_ena[4] net1[4] source_ena_b_5v0[4] avdd avss level_shift_5v
x9[3] source_ena[3] net1[3] source_ena_b_5v0[3] avdd avss level_shift_5v
x9[2] source_ena[2] net1[2] source_ena_b_5v0[2] avdd avss level_shift_5v
x9[1] source_ena[1] net1[1] source_ena_b_5v0[1] avdd avss level_shift_5v
x9[0] source_ena[0] net1[0] source_ena_b_5v0[0] avdd avss level_shift_5v
x46[4] dvdd dvdd dvss dvss net1[4] source_ena[4] gf180mcu_as_sc_mcu7t3v3__inv_2
x46[3] dvdd dvdd dvss dvss net1[3] source_ena[3] gf180mcu_as_sc_mcu7t3v3__inv_2
x46[2] dvdd dvdd dvss dvss net1[2] source_ena[2] gf180mcu_as_sc_mcu7t3v3__inv_2
x46[1] dvdd dvdd dvss dvss net1[1] source_ena[1] gf180mcu_as_sc_mcu7t3v3__inv_2
x46[0] dvdd dvdd dvss dvss net1[0] source_ena[0] gf180mcu_as_sc_mcu7t3v3__inv_2
x23[4] dvdd dvdd dvss dvss gf180mcu_as_sc_mcu7t3v3__fillcap_4
x23[3] dvdd dvdd dvss dvss gf180mcu_as_sc_mcu7t3v3__fillcap_4
x23[2] dvdd dvdd dvss dvss gf180mcu_as_sc_mcu7t3v3__fillcap_4
x23[1] dvdd dvdd dvss dvss gf180mcu_as_sc_mcu7t3v3__fillcap_4
x23[0] dvdd dvdd dvss dvss gf180mcu_as_sc_mcu7t3v3__fillcap_4
x78[4] dvdd dvdd dvss dvss source_ena[4] gf180mcu_as_sc_mcu7t3v3__diode_2
x78[3] dvdd dvdd dvss dvss source_ena[3] gf180mcu_as_sc_mcu7t3v3__diode_2
x78[2] dvdd dvdd dvss dvss source_ena[2] gf180mcu_as_sc_mcu7t3v3__diode_2
x78[1] dvdd dvdd dvss dvss source_ena[1] gf180mcu_as_sc_mcu7t3v3__diode_2
x78[0] dvdd dvdd dvss dvss source_ena[0] gf180mcu_as_sc_mcu7t3v3__diode_2
x9 avdd pbias pcasc source_ena_b_5v0[0] source_ibias shld2 shld3 bias_pstack
x10[1] avdd pbias pcasc source_ena_b_5v0[1] source_ibias shld2 shld3 bias_pstack
x10[0] avdd pbias pcasc source_ena_b_5v0[1] source_ibias shld2 shld3 bias_pstack
x1[3] avdd pbias pcasc source_ena_b_5v0[2] source_ibias shld2 shld3 bias_pstack
x1[2] avdd pbias pcasc source_ena_b_5v0[2] source_ibias shld2 shld3 bias_pstack
x1[1] avdd pbias pcasc source_ena_b_5v0[2] source_ibias shld2 shld3 bias_pstack
x1[0] avdd pbias pcasc source_ena_b_5v0[2] source_ibias shld2 shld3 bias_pstack
x2[7] avdd pbias pcasc source_ena_b_5v0[3] source_ibias shld2 shld3 bias_pstack
x2[6] avdd pbias pcasc source_ena_b_5v0[3] source_ibias shld2 shld3 bias_pstack
x2[5] avdd pbias pcasc source_ena_b_5v0[3] source_ibias shld2 shld3 bias_pstack
x2[4] avdd pbias pcasc source_ena_b_5v0[3] source_ibias shld2 shld3 bias_pstack
x2[3] avdd pbias pcasc source_ena_b_5v0[3] source_ibias shld2 shld3 bias_pstack
x2[2] avdd pbias pcasc source_ena_b_5v0[3] source_ibias shld2 shld3 bias_pstack
x2[1] avdd pbias pcasc source_ena_b_5v0[3] source_ibias shld2 shld3 bias_pstack
x2[0] avdd pbias pcasc source_ena_b_5v0[3] source_ibias shld2 shld3 bias_pstack
x3[15] avdd pbias pcasc source_ena_b_5v0[4] source_ibias shld2 shld3 bias_pstack
x3[14] avdd pbias pcasc source_ena_b_5v0[4] source_ibias shld2 shld3 bias_pstack
x3[13] avdd pbias pcasc source_ena_b_5v0[4] source_ibias shld2 shld3 bias_pstack
x3[12] avdd pbias pcasc source_ena_b_5v0[4] source_ibias shld2 shld3 bias_pstack
x3[11] avdd pbias pcasc source_ena_b_5v0[4] source_ibias shld2 shld3 bias_pstack
x3[10] avdd pbias pcasc source_ena_b_5v0[4] source_ibias shld2 shld3 bias_pstack
x3[9] avdd pbias pcasc source_ena_b_5v0[4] source_ibias shld2 shld3 bias_pstack
x3[8] avdd pbias pcasc source_ena_b_5v0[4] source_ibias shld2 shld3 bias_pstack
x3[7] avdd pbias pcasc source_ena_b_5v0[4] source_ibias shld2 shld3 bias_pstack
x3[6] avdd pbias pcasc source_ena_b_5v0[4] source_ibias shld2 shld3 bias_pstack
x3[5] avdd pbias pcasc source_ena_b_5v0[4] source_ibias shld2 shld3 bias_pstack
x3[4] avdd pbias pcasc source_ena_b_5v0[4] source_ibias shld2 shld3 bias_pstack
x3[3] avdd pbias pcasc source_ena_b_5v0[4] source_ibias shld2 shld3 bias_pstack
x3[2] avdd pbias pcasc source_ena_b_5v0[4] source_ibias shld2 shld3 bias_pstack
x3[1] avdd pbias pcasc source_ena_b_5v0[4] source_ibias shld2 shld3 bias_pstack
x3[0] avdd pbias pcasc source_ena_b_5v0[4] source_ibias shld2 shld3 bias_pstack
x4[4] dvss dvdd gf180mcu_as_sc_mcu7t3v3__tap_2
x4[3] dvss dvdd gf180mcu_as_sc_mcu7t3v3__tap_2
x4[2] dvss dvdd gf180mcu_as_sc_mcu7t3v3__tap_2
x4[1] dvss dvdd gf180mcu_as_sc_mcu7t3v3__tap_2
x4[0] dvss dvdd gf180mcu_as_sc_mcu7t3v3__tap_2
.ends

* expanding   symbol:  bias_nstack.sym # of pins=7
** sym_path: /home/tim/gits/gf180mcu_ocd_chipalooza/dependencies/gf180mcu_ocd_ip__biasgen/xschem/bias_nstack.sym
** sch_path: /home/tim/gits/gf180mcu_ocd_chipalooza/dependencies/gf180mcu_ocd_ip__biasgen/xschem/bias_nstack.sch
.subckt bias_nstack itail ena ncasc nbias avss shld2 shld3
*.PININFO avss:B ena:I nbias:I itail:B ncasc:I shld2:B shld3:B
XM1 itail ena net2 avss nfet_05v0 L=1.0u W=3.0u nf=1 ad='int((nf+1)/2) * W/nf * 0.18u' as='int((nf+2)/2) * W/nf * 0.18u' pd='2*int((nf+1)/2) * (W/nf + 0.18u)'
+ ps='2*int((nf+2)/2) * (W/nf + 0.18u)' nrd='0.18u / W' nrs='0.18u / W' sa=0 sb=0 sd=0 m=1 par=1
XM2 net2 ncasc net1 avss nfet_05v0 L=1.0u W=3.0u nf=1 ad='int((nf+1)/2) * W/nf * 0.18u' as='int((nf+2)/2) * W/nf * 0.18u' pd='2*int((nf+1)/2) * (W/nf + 0.18u)'
+ ps='2*int((nf+2)/2) * (W/nf + 0.18u)' nrd='0.18u / W' nrs='0.18u / W' sa=0 sb=0 sd=0 m=1 par=1
XM3 net1 nbias avss avss nfet_05v0 L=1.0u W=3.0u nf=1 ad='int((nf+1)/2) * W/nf * 0.18u' as='int((nf+2)/2) * W/nf * 0.18u' pd='2*int((nf+1)/2) * (W/nf + 0.18u)'
+ ps='2*int((nf+2)/2) * (W/nf + 0.18u)' nrd='0.18u / W' nrs='0.18u / W' sa=0 sb=0 sd=0 m=1 par=1
.ends

* expanding   symbol:  bias_pstack.sym # of pins=7
** sym_path: /home/tim/gits/gf180mcu_ocd_chipalooza/dependencies/gf180mcu_ocd_ip__biasgen/xschem/bias_pstack.sym
** sch_path: /home/tim/gits/gf180mcu_ocd_chipalooza/dependencies/gf180mcu_ocd_ip__biasgen/xschem/bias_pstack.sch
.subckt bias_pstack avdd pbias pcasc enb itail shld2 shld3
*.PININFO avdd:B itail:B enb:I pcasc:I pbias:I shld2:B shld3:B
XM1 net1 pbias avdd avdd pfet_05v0 L=1.0u W=3.0u nf=1 ad='int((nf+1)/2) * W/nf * 0.18u' as='int((nf+2)/2) * W/nf * 0.18u' pd='2*int((nf+1)/2) * (W/nf + 0.18u)'
+ ps='2*int((nf+2)/2) * (W/nf + 0.18u)' nrd='0.18u / W' nrs='0.18u / W' sa=0 sb=0 sd=0 m=1 par=1
XM2 net2 pcasc net1 avdd pfet_05v0 L=1.0u W=3.0u nf=1 ad='int((nf+1)/2) * W/nf * 0.18u' as='int((nf+2)/2) * W/nf * 0.18u' pd='2*int((nf+1)/2) * (W/nf + 0.18u)'
+ ps='2*int((nf+2)/2) * (W/nf + 0.18u)' nrd='0.18u / W' nrs='0.18u / W' sa=0 sb=0 sd=0 m=1 par=1
XM3 itail enb net2 avdd pfet_05v0 L=1.0u W=3.0u nf=1 ad='int((nf+1)/2) * W/nf * 0.18u' as='int((nf+2)/2) * W/nf * 0.18u' pd='2*int((nf+1)/2) * (W/nf + 0.18u)'
+ ps='2*int((nf+2)/2) * (W/nf + 0.18u)' nrd='0.18u / W' nrs='0.18u / W' sa=0 sb=0 sd=0 m=1 par=1
.ends

* expanding   symbol:  bias_generator_ben1um.sym # of pins=10
** sym_path: /home/tim/gits/gf180mcu_ocd_chipalooza/dependencies/gf180mcu_ocd_ip__biasgen/xschem/bias_generator_ben1um.sym
** sch_path: /home/tim/gits/gf180mcu_ocd_chipalooza/dependencies/gf180mcu_ocd_ip__biasgen/xschem/bias_generator_ben1um.sch
.subckt bias_generator_ben1um dvdd dvss avdd nbias avss sink_ena[2] sink_ena[1] sink_ena[0] sink_ibias ncasc shld2 shld3
*.PININFO avss:B avdd:B dvdd:B dvss:B nbias:I ncasc:I sink_ibias:B sink_ena[2:0]:I shld2:B shld3:B
x7[2] dvdd dvdd dvss dvss gf180mcu_as_sc_mcu7t3v3__fillcap_4
x7[1] dvdd dvdd dvss dvss gf180mcu_as_sc_mcu7t3v3__fillcap_4
x7[0] dvdd dvdd dvss dvss gf180mcu_as_sc_mcu7t3v3__fillcap_4
x6[2] dvdd dvdd dvss dvss sink_ena[2] gf180mcu_as_sc_mcu7t3v3__diode_2
x6[1] dvdd dvdd dvss dvss sink_ena[1] gf180mcu_as_sc_mcu7t3v3__diode_2
x6[0] dvdd dvdd dvss dvss sink_ena[0] gf180mcu_as_sc_mcu7t3v3__diode_2
x1[2] sink_ibias sink_ena_5v0[0] ncasc nbias avss shld2 shld3 bias_nstack
x1[1] sink_ibias sink_ena_5v0[0] ncasc nbias avss shld2 shld3 bias_nstack
x1[0] sink_ibias sink_ena_5v0[0] ncasc nbias avss shld2 shld3 bias_nstack
x2 sink_ibias sink_ena_5v0[1] ncasc nbias avss shld2 shld3 bias_nstack
x3 sink_ibias sink_ena_5v0[2] ncasc nbias avss shld2 shld3 bias_nstack
x4[2] net1[2] sink_ena[2] sink_ena_5v0[2] avdd avss level_shift_5v
x4[1] net1[1] sink_ena[1] sink_ena_5v0[1] avdd avss level_shift_5v
x4[0] net1[0] sink_ena[0] sink_ena_5v0[0] avdd avss level_shift_5v
x5[2] dvdd dvdd dvss dvss net1[2] sink_ena[2] gf180mcu_as_sc_mcu7t3v3__inv_2
x5[1] dvdd dvdd dvss dvss net1[1] sink_ena[1] gf180mcu_as_sc_mcu7t3v3__inv_2
x5[0] dvdd dvdd dvss dvss net1[0] sink_ena[0] gf180mcu_as_sc_mcu7t3v3__inv_2
x2[9] dummy_ibias avss ncasc nbias avss shld2 shld3 bias_nstack
x2[8] dummy_ibias avss ncasc nbias avss shld2 shld3 bias_nstack
x2[7] dummy_ibias avss ncasc nbias avss shld2 shld3 bias_nstack
x2[6] dummy_ibias avss ncasc nbias avss shld2 shld3 bias_nstack
x2[5] dummy_ibias avss ncasc nbias avss shld2 shld3 bias_nstack
x2[4] dummy_ibias avss ncasc nbias avss shld2 shld3 bias_nstack
x2[3] dummy_ibias avss ncasc nbias avss shld2 shld3 bias_nstack
x2[2] dummy_ibias avss ncasc nbias avss shld2 shld3 bias_nstack
x2[1] dummy_ibias avss ncasc nbias avss shld2 shld3 bias_nstack
x2[0] dummy_ibias avss ncasc nbias avss shld2 shld3 bias_nstack
x3[2] dvss dvdd gf180mcu_as_sc_mcu7t3v3__tap_2
x3[1] dvss dvdd gf180mcu_as_sc_mcu7t3v3__tap_2
x3[0] dvss dvdd gf180mcu_as_sc_mcu7t3v3__tap_2
.ends

* expanding   symbol:  bias_generator_ben250nm.sym # of pins=10
** sym_path: /home/tim/gits/gf180mcu_ocd_chipalooza/dependencies/gf180mcu_ocd_ip__biasgen/xschem/bias_generator_ben250nm.sym
** sch_path: /home/tim/gits/gf180mcu_ocd_chipalooza/dependencies/gf180mcu_ocd_ip__biasgen/xschem/bias_generator_ben250nm.sch
.subckt bias_generator_ben250nm dvdd dvss avdd nbias avss sink_ena[1] sink_ena[0] sink_ibias ncasc shld2 shld3
*.PININFO avss:B avdd:B dvdd:B dvss:B nbias:I ncasc:I sink_ibias:B sink_ena[1:0]:I shld2:B shld3:B
x7[1] dvdd dvdd dvss dvss gf180mcu_as_sc_mcu7t3v3__fillcap_4
x7[0] dvdd dvdd dvss dvss gf180mcu_as_sc_mcu7t3v3__fillcap_4
x6[1] dvdd dvdd dvss dvss sink_ena[1] gf180mcu_as_sc_mcu7t3v3__diode_2
x6[0] dvdd dvdd dvss dvss sink_ena[0] gf180mcu_as_sc_mcu7t3v3__diode_2
x2 sink_ibias sink_ena_5v0[1] ncasc nbias avss shld2 shld3 bias_nstack
x3 sink_ibias sink_ena_5v0[0] ncasc nbias avss shld2 shld3 bias_nstack
x4[1] net1[1] sink_ena[1] sink_ena_5v0[1] avdd avss level_shift_5v
x4[0] net1[0] sink_ena[0] sink_ena_5v0[0] avdd avss level_shift_5v
x5[1] dvdd dvdd dvss dvss net1[1] sink_ena[1] gf180mcu_as_sc_mcu7t3v3__inv_2
x5[0] dvdd dvdd dvss dvss net1[0] sink_ena[0] gf180mcu_as_sc_mcu7t3v3__inv_2
x1[7] dummy_bias avss ncasc nbias avss shld2 shld3 bias_nstack
x1[6] dummy_bias avss ncasc nbias avss shld2 shld3 bias_nstack
x1[5] dummy_bias avss ncasc nbias avss shld2 shld3 bias_nstack
x1[4] dummy_bias avss ncasc nbias avss shld2 shld3 bias_nstack
x1[3] dummy_bias avss ncasc nbias avss shld2 shld3 bias_nstack
x1[2] dummy_bias avss ncasc nbias avss shld2 shld3 bias_nstack
x1[1] dummy_bias avss ncasc nbias avss shld2 shld3 bias_nstack
x1[0] dummy_bias avss ncasc nbias avss shld2 shld3 bias_nstack
x2[1] dvss dvdd gf180mcu_as_sc_mcu7t3v3__tap_2
x2[0] dvss dvdd gf180mcu_as_sc_mcu7t3v3__tap_2
.ends

* expanding   symbol:  bandgap_unbuffered.sym # of pins=7
** sym_path: /home/tim/gits/gf180mcu_ocd_chipalooza/dependencies/gf180mcu_ocd_ip__biasgen/xschem/bandgap_unbuffered.sym
** sch_path: /home/tim/gits/gf180mcu_ocd_chipalooza/dependencies/gf180mcu_ocd_ip__biasgen/xschem/bandgap_unbuffered.sch
.subckt bandgap_unbuffered vbg bias trim[15] trim[14] trim[13] trim[12] trim[11] trim[10] trim[9] trim[8] trim[7] trim[6] trim[5]
+ trim[4] trim[3] trim[2] trim[1] trim[0] dvss dvdd ena ena_buf
*.PININFO vbg:O bias:B trim[15:0]:I dvss:B dvdd:B ena:I ena_buf:O
xres vbg comp vp vn dvss net4 dvss dvss vp dvss dvss bg_res
xtr net1 net2 net5[15] net5[14] net5[13] net5[12] net5[11] net5[10] net5[9] net5[8] net5[7] net5[6] net5[5] net5[4] net5[3]
+ net5[2] net5[1] net5[0] dvss bg_trim
xamp dvdd gate vp vn dvss bias ena_buf se_folded_cascode_p
x2 dvdd dvdd dvss dvss ena gf180mcu_as_sc_mcu7t3v3__diode_2
x3[15] dvdd dvdd dvss dvss trim[15] gf180mcu_as_sc_mcu7t3v3__diode_2
x3[14] dvdd dvdd dvss dvss trim[14] gf180mcu_as_sc_mcu7t3v3__diode_2
x3[13] dvdd dvdd dvss dvss trim[13] gf180mcu_as_sc_mcu7t3v3__diode_2
x3[12] dvdd dvdd dvss dvss trim[12] gf180mcu_as_sc_mcu7t3v3__diode_2
x3[11] dvdd dvdd dvss dvss trim[11] gf180mcu_as_sc_mcu7t3v3__diode_2
x3[10] dvdd dvdd dvss dvss trim[10] gf180mcu_as_sc_mcu7t3v3__diode_2
x3[9] dvdd dvdd dvss dvss trim[9] gf180mcu_as_sc_mcu7t3v3__diode_2
x3[8] dvdd dvdd dvss dvss trim[8] gf180mcu_as_sc_mcu7t3v3__diode_2
x3[7] dvdd dvdd dvss dvss trim[7] gf180mcu_as_sc_mcu7t3v3__diode_2
x3[6] dvdd dvdd dvss dvss trim[6] gf180mcu_as_sc_mcu7t3v3__diode_2
x3[5] dvdd dvdd dvss dvss trim[5] gf180mcu_as_sc_mcu7t3v3__diode_2
x3[4] dvdd dvdd dvss dvss trim[4] gf180mcu_as_sc_mcu7t3v3__diode_2
x3[3] dvdd dvdd dvss dvss trim[3] gf180mcu_as_sc_mcu7t3v3__diode_2
x3[2] dvdd dvdd dvss dvss trim[2] gf180mcu_as_sc_mcu7t3v3__diode_2
x3[1] dvdd dvdd dvss dvss trim[1] gf180mcu_as_sc_mcu7t3v3__diode_2
x3[0] dvdd dvdd dvss dvss trim[0] gf180mcu_as_sc_mcu7t3v3__diode_2
x4[2] dvss dvdd gf180mcu_as_sc_mcu7t3v3__tap_2
x4[1] dvss dvdd gf180mcu_as_sc_mcu7t3v3__tap_2
x4[0] dvss dvdd gf180mcu_as_sc_mcu7t3v3__tap_2
XQ3 dvss dvss net2 pnp_05p00x05p00 m=8 par=8
XQ1 dvss dvss net3 pnp_05p00x05p00 m=1 par=1
XC1 vs2 dvss cap_mim_2f0_m4m5_noshield c_width=22e-6 c_length=22e-6 m=1
XC3 gate dvss cap_mim_2f0_m4m5_noshield c_width=22e-6 c_length=22e-6 m=2
XM8 comp gate dvdd dvdd pfet_03v3 L=0.5u W=4u nf=1 ad='int((nf+1)/2) * W/nf * 0.18u' as='int((nf+2)/2) * W/nf * 0.18u' pd='2*int((nf+1)/2) * (W/nf + 0.18u)'
+ ps='2*int((nf+2)/2) * (W/nf + 0.18u)' nrd='0.18u / W' nrs='0.18u / W' sa=0 sb=0 sd=0 m=2 par=2
XM1 vbg gate dvdd dvdd pfet_03v3 L=0.5u W=4u nf=1 ad='int((nf+1)/2) * W/nf * 0.18u' as='int((nf+2)/2) * W/nf * 0.18u' pd='2*int((nf+1)/2) * (W/nf + 0.18u)'
+ ps='2*int((nf+2)/2) * (W/nf + 0.18u)' nrd='0.18u / W' nrs='0.18u / W' sa=0 sb=0 sd=0 m=2 par=2
XM2 vs1 vbg dvss dvss nfet_03v3 L=1u W=1u nf=1 ad='int((nf+1)/2) * W/nf * 0.18u' as='int((nf+2)/2) * W/nf * 0.18u' pd='2*int((nf+1)/2) * (W/nf + 0.18u)'
+ ps='2*int((nf+2)/2) * (W/nf + 0.18u)' nrd='0.18u / W' nrs='0.18u / W' sa=0 sb=0 sd=0 m=1 par=1
XM9 vs1 vs2 dvdd dvdd pfet_03v3 L=1u W=1u nf=1 ad='int((nf+1)/2) * W/nf * 0.18u' as='int((nf+2)/2) * W/nf * 0.18u' pd='2*int((nf+1)/2) * (W/nf + 0.18u)'
+ ps='2*int((nf+2)/2) * (W/nf + 0.18u)' nrd='0.18u / W' nrs='0.18u / W' sa=0 sb=0 sd=0 m=1 par=1
XM5 vs2 vs2 dvdd dvdd pfet_03v3 L=1u W=1u nf=1 ad='int((nf+1)/2) * W/nf * 0.18u' as='int((nf+2)/2) * W/nf * 0.18u' pd='2*int((nf+1)/2) * (W/nf + 0.18u)'
+ ps='2*int((nf+2)/2) * (W/nf + 0.18u)' nrd='0.18u / W' nrs='0.18u / W' sa=0 sb=0 sd=0 m=1 par=1
XM6 dvss dvdd vs2 vs2 pfet_03v3 L=1u W=1u nf=1 ad='int((nf+1)/2) * W/nf * 0.18u' as='int((nf+2)/2) * W/nf * 0.18u' pd='2*int((nf+1)/2) * (W/nf + 0.18u)'
+ ps='2*int((nf+2)/2) * (W/nf + 0.18u)' nrd='0.18u / W' nrs='0.18u / W' sa=0 sb=0 sd=0 m=1 par=1
XM3 gate vs1 dvss dvss nfet_03v3 L=1u W=1u nf=1 ad='int((nf+1)/2) * W/nf * 0.18u' as='int((nf+2)/2) * W/nf * 0.18u' pd='2*int((nf+1)/2) * (W/nf + 0.18u)'
+ ps='2*int((nf+2)/2) * (W/nf + 0.18u)' nrd='0.18u / W' nrs='0.18u / W' sa=0 sb=0 sd=0 m=1 par=1
Vmeas vn net3 0
.save i(vmeas)
Vmeas1 net4 net1 0
.save i(vmeas1)
x1 dvdd dvdd dvss dvss ena ena_buf gf180mcu_as_sc_mcu7t3v3__buff_2
x1[15] dvdd dvdd dvss dvss trim[15] net5[15] gf180mcu_as_sc_mcu7t3v3__buff_2
x1[14] dvdd dvdd dvss dvss trim[14] net5[14] gf180mcu_as_sc_mcu7t3v3__buff_2
x1[13] dvdd dvdd dvss dvss trim[13] net5[13] gf180mcu_as_sc_mcu7t3v3__buff_2
x1[12] dvdd dvdd dvss dvss trim[12] net5[12] gf180mcu_as_sc_mcu7t3v3__buff_2
x1[11] dvdd dvdd dvss dvss trim[11] net5[11] gf180mcu_as_sc_mcu7t3v3__buff_2
x1[10] dvdd dvdd dvss dvss trim[10] net5[10] gf180mcu_as_sc_mcu7t3v3__buff_2
x1[9] dvdd dvdd dvss dvss trim[9] net5[9] gf180mcu_as_sc_mcu7t3v3__buff_2
x1[8] dvdd dvdd dvss dvss trim[8] net5[8] gf180mcu_as_sc_mcu7t3v3__buff_2
x1[7] dvdd dvdd dvss dvss trim[7] net5[7] gf180mcu_as_sc_mcu7t3v3__buff_2
x1[6] dvdd dvdd dvss dvss trim[6] net5[6] gf180mcu_as_sc_mcu7t3v3__buff_2
x1[5] dvdd dvdd dvss dvss trim[5] net5[5] gf180mcu_as_sc_mcu7t3v3__buff_2
x1[4] dvdd dvdd dvss dvss trim[4] net5[4] gf180mcu_as_sc_mcu7t3v3__buff_2
x1[3] dvdd dvdd dvss dvss trim[3] net5[3] gf180mcu_as_sc_mcu7t3v3__buff_2
x1[2] dvdd dvdd dvss dvss trim[2] net5[2] gf180mcu_as_sc_mcu7t3v3__buff_2
x1[1] dvdd dvdd dvss dvss trim[1] net5[1] gf180mcu_as_sc_mcu7t3v3__buff_2
x1[0] dvdd dvdd dvss dvss trim[0] net5[0] gf180mcu_as_sc_mcu7t3v3__buff_2
.ends

* expanding   symbol:  sw_lvl_shift.sym # of pins=4
** sym_path: /home/tim/gits/gf180mcu_ocd_chipalooza/dependencies/gf180mcu_ocd_ip__analog_switches/xschem/sw_lvl_shift.sym
** sch_path: /home/tim/gits/gf180mcu_ocd_chipalooza/dependencies/gf180mcu_ocd_ip__analog_switches/xschem/sw_lvl_shift.sch
.subckt sw_lvl_shift in_p in_n out outn avdd avss
*.PININFO in_n:I in_p:I out:O outn:O
XM9 net1 S1_N avdd avdd pfet_05v0 L=0.50u W=0.50u nf=1 ad='int((nf+1)/2) * W/nf * 0.18u' as='int((nf+2)/2) * W/nf * 0.18u' pd='2*int((nf+1)/2) * (W/nf + 0.18u)'
+ ps='2*int((nf+2)/2) * (W/nf + 0.18u)' nrd='0.18u / W' nrs='0.18u / W' sa=0 sb=0 sd=0 m=1 par=1
XM10 S1_N net1 avdd avdd pfet_05v0 L=0.50u W=0.50u nf=1 ad='int((nf+1)/2) * W/nf * 0.18u' as='int((nf+2)/2) * W/nf * 0.18u' pd='2*int((nf+1)/2) * (W/nf + 0.18u)'
+ ps='2*int((nf+2)/2) * (W/nf + 0.18u)' nrd='0.18u / W' nrs='0.18u / W' sa=0 sb=0 sd=0 m=1 par=1
XM11 outn S1_N avdd avdd pfet_05v0 L=0.50u W=2.0u nf=1 ad='int((nf+1)/2) * W/nf * 0.18u' as='int((nf+2)/2) * W/nf * 0.18u' pd='2*int((nf+1)/2) * (W/nf + 0.18u)'
+ ps='2*int((nf+2)/2) * (W/nf + 0.18u)' nrd='0.18u / W' nrs='0.18u / W' sa=0 sb=0 sd=0 m=2 par=2
XM12 out outn avdd avdd pfet_05v0 L=0.50u W=2.0u nf=1 ad='int((nf+1)/2) * W/nf * 0.18u' as='int((nf+2)/2) * W/nf * 0.18u' pd='2*int((nf+1)/2) * (W/nf + 0.18u)'
+ ps='2*int((nf+2)/2) * (W/nf + 0.18u)' nrd='0.18u / W' nrs='0.18u / W' sa=0 sb=0 sd=0 m=2 par=2
XM13 net1 in_p avss avss nfet_05v0 L=0.60u W=2.0u nf=1 ad='int((nf+1)/2) * W/nf * 0.18u' as='int((nf+2)/2) * W/nf * 0.18u' pd='2*int((nf+1)/2) * (W/nf + 0.18u)'
+ ps='2*int((nf+2)/2) * (W/nf + 0.18u)' nrd='0.18u / W' nrs='0.18u / W' sa=0 sb=0 sd=0 m=1 par=1
XM14 S1_N in_n avss avss nfet_05v0 L=0.60u W=2.0u nf=1 ad='int((nf+1)/2) * W/nf * 0.18u' as='int((nf+2)/2) * W/nf * 0.18u' pd='2*int((nf+1)/2) * (W/nf + 0.18u)'
+ ps='2*int((nf+2)/2) * (W/nf + 0.18u)' nrd='0.18u / W' nrs='0.18u / W' sa=0 sb=0 sd=0 m=1 par=1
XM15 outn S1_N avss avss nfet_05v0 L=0.60u W=1.0u nf=1 ad='int((nf+1)/2) * W/nf * 0.18u' as='int((nf+2)/2) * W/nf * 0.18u' pd='2*int((nf+1)/2) * (W/nf + 0.18u)'
+ ps='2*int((nf+2)/2) * (W/nf + 0.18u)' nrd='0.18u / W' nrs='0.18u / W' sa=0 sb=0 sd=0 m=2 par=2
XM16 out outn avss avss nfet_05v0 L=0.60u W=1.0u nf=1 ad='int((nf+1)/2) * W/nf * 0.18u' as='int((nf+2)/2) * W/nf * 0.18u' pd='2*int((nf+1)/2) * (W/nf + 0.18u)'
+ ps='2*int((nf+2)/2) * (W/nf + 0.18u)' nrd='0.18u / W' nrs='0.18u / W' sa=0 sb=0 sd=0 m=2 par=2
.ends

* expanding   symbol:  gate_drive_med.sym # of pins=6
** sym_path: /home/tim/gits/gf180mcu_ocd_chipalooza/dependencies/gf180mcu_ocd_ip__analog_switches/xschem/gate_drive_med.sym
** sch_path: /home/tim/gits/gf180mcu_ocd_chipalooza/dependencies/gf180mcu_ocd_ip__analog_switches/xschem/gate_drive_med.sch
.subckt gate_drive_med in_n in_p out vdd vss outn
*.PININFO in_n:I in_p:I vdd:I vss:I out:O outn:O
XM13 net1 S1_P vdd vdd pfet_05v0 L=0.50u W=0.50u nf=1 ad='int((nf+1)/2) * W/nf * 0.18u' as='int((nf+2)/2) * W/nf * 0.18u' pd='2*int((nf+1)/2) * (W/nf + 0.18u)'
+ ps='2*int((nf+2)/2) * (W/nf + 0.18u)' nrd='0.18u / W' nrs='0.18u / W' sa=0 sb=0 sd=0 m=1 par=1
XM14 net1 in_p vss vss nfet_05v0 L=0.60u W=2.0u nf=1 ad='int((nf+1)/2) * W/nf * 0.18u' as='int((nf+2)/2) * W/nf * 0.18u' pd='2*int((nf+1)/2) * (W/nf + 0.18u)'
+ ps='2*int((nf+2)/2) * (W/nf + 0.18u)' nrd='0.18u / W' nrs='0.18u / W' sa=0 sb=0 sd=0 m=1 par=1
XM15 S1_P in_n vss vss nfet_05v0 L=0.60u W=2.0u nf=1 ad='int((nf+1)/2) * W/nf * 0.18u' as='int((nf+2)/2) * W/nf * 0.18u' pd='2*int((nf+1)/2) * (W/nf + 0.18u)'
+ ps='2*int((nf+2)/2) * (W/nf + 0.18u)' nrd='0.18u / W' nrs='0.18u / W' sa=0 sb=0 sd=0 m=1 par=1
XM16 S1_P net1 vdd vdd pfet_05v0 L=0.50u W=0.50u nf=1 ad='int((nf+1)/2) * W/nf * 0.18u' as='int((nf+2)/2) * W/nf * 0.18u' pd='2*int((nf+1)/2) * (W/nf + 0.18u)'
+ ps='2*int((nf+2)/2) * (W/nf + 0.18u)' nrd='0.18u / W' nrs='0.18u / W' sa=0 sb=0 sd=0 m=1 par=1
XM18 S2_N S1_P vss vss nfet_05v0 L=0.60u W=5.0u nf=1 ad='int((nf+1)/2) * W/nf * 0.18u' as='int((nf+2)/2) * W/nf * 0.18u' pd='2*int((nf+1)/2) * (W/nf + 0.18u)'
+ ps='2*int((nf+2)/2) * (W/nf + 0.18u)' nrd='0.18u / W' nrs='0.18u / W' sa=0 sb=0 sd=0 m=2 par=2
XM19 S3_P S2_N vss vss nfet_05v0 L=0.60u W=5.0u nf=1 ad='int((nf+1)/2) * W/nf * 0.18u' as='int((nf+2)/2) * W/nf * 0.18u' pd='2*int((nf+1)/2) * (W/nf + 0.18u)'
+ ps='2*int((nf+2)/2) * (W/nf + 0.18u)' nrd='0.18u / W' nrs='0.18u / W' sa=0 sb=0 sd=0 m=6 par=6
XM21 outn S3_P vss vss nfet_05v0 L=0.60u W=5.0u nf=1 ad='int((nf+1)/2) * W/nf * 0.18u' as='int((nf+2)/2) * W/nf * 0.18u' pd='2*int((nf+1)/2) * (W/nf + 0.18u)'
+ ps='2*int((nf+2)/2) * (W/nf + 0.18u)' nrd='0.18u / W' nrs='0.18u / W' sa=0 sb=0 sd=0 m=16 par=16
XM23 out outn vss vss nfet_05v0 L=0.60u W=5.0u nf=1 ad='int((nf+1)/2) * W/nf * 0.18u' as='int((nf+2)/2) * W/nf * 0.18u' pd='2*int((nf+1)/2) * (W/nf + 0.18u)'
+ ps='2*int((nf+2)/2) * (W/nf + 0.18u)' nrd='0.18u / W' nrs='0.18u / W' sa=0 sb=0 sd=0 m=16 par=16
XM1 S2_N S1_P vdd vdd pfet_06v0 L=0.6u W=10.0u nf=1 ad='int((nf+1)/2) * W/nf * 0.18u' as='int((nf+2)/2) * W/nf * 0.18u' pd='2*int((nf+1)/2) * (W/nf + 0.18u)'
+ ps='2*int((nf+2)/2) * (W/nf + 0.18u)' nrd='0.18u / W' nrs='0.18u / W' sa=0 sb=0 sd=0 m=2 par=2
XM2 S3_P S2_N vdd vdd pfet_06v0 L=0.6u W=10.0u nf=1 ad='int((nf+1)/2) * W/nf * 0.18u' as='int((nf+2)/2) * W/nf * 0.18u' pd='2*int((nf+1)/2) * (W/nf + 0.18u)'
+ ps='2*int((nf+2)/2) * (W/nf + 0.18u)' nrd='0.18u / W' nrs='0.18u / W' sa=0 sb=0 sd=0 m=6 par=6
XM3 outn S3_P vdd vdd pfet_06v0 L=0.6u W=10.0u nf=1 ad='int((nf+1)/2) * W/nf * 0.18u' as='int((nf+2)/2) * W/nf * 0.18u' pd='2*int((nf+1)/2) * (W/nf + 0.18u)'
+ ps='2*int((nf+2)/2) * (W/nf + 0.18u)' nrd='0.18u / W' nrs='0.18u / W' sa=0 sb=0 sd=0 m=16 par=16
XM4 out outn vdd vdd pfet_06v0 L=0.6u W=10.0u nf=1 ad='int((nf+1)/2) * W/nf * 0.18u' as='int((nf+2)/2) * W/nf * 0.18u' pd='2*int((nf+1)/2) * (W/nf + 0.18u)'
+ ps='2*int((nf+2)/2) * (W/nf + 0.18u)' nrd='0.18u / W' nrs='0.18u / W' sa=0 sb=0 sd=0 m=16 par=16
.ends

* expanding   symbol:  gate_drive_3v3.sym # of pins=4
** sym_path: /home/tim/gits/gf180mcu_ocd_chipalooza/dependencies/gf180mcu_ocd_ip__analog_switches/xschem/gate_drive_3v3.sym
** sch_path: /home/tim/gits/gf180mcu_ocd_chipalooza/dependencies/gf180mcu_ocd_ip__analog_switches/xschem/gate_drive_3v3.sch
.subckt gate_drive_3v3 dvdd dvss out in
*.PININFO in:I dvdd:B dvss:B out:O
XM1 net2 net1 dvdd dvdd pfet_03v3 L=0.28u W=11.04u nf=8 ad='int((nf+1)/2) * W/nf * 0.18u' as='int((nf+2)/2) * W/nf * 0.18u' pd='2*int((nf+1)/2) * (W/nf + 0.18u)'
+ ps='2*int((nf+2)/2) * (W/nf + 0.18u)' nrd='0.18u / W' nrs='0.18u / W' sa=0 sb=0 sd=0 m=1 par=1
XM2 net2 net1 dvss dvss nfet_03v3 L=0.28u W=8.0u nf=8 ad='int((nf+1)/2) * W/nf * 0.18u' as='int((nf+2)/2) * W/nf * 0.18u' pd='2*int((nf+1)/2) * (W/nf + 0.18u)'
+ ps='2*int((nf+2)/2) * (W/nf + 0.18u)' nrd='0.18u / W' nrs='0.18u / W' sa=0 sb=0 sd=0 m=1 par=1
x3 dvdd dvdd dvss dvss net1 in gf180mcu_as_sc_mcu7t3v3__inv_2
x2 dvdd dvdd dvss dvss in gf180mcu_as_sc_mcu7t3v3__diode_2
x4[1] dvdd dvdd dvss dvss gf180mcu_as_sc_mcu7t3v3__fillcap_4
x4[0] dvdd dvdd dvss dvss gf180mcu_as_sc_mcu7t3v3__fillcap_4
x5[1] dvss dvdd gf180mcu_as_sc_mcu7t3v3__tap_2
x5[0] dvss dvdd gf180mcu_as_sc_mcu7t3v3__tap_2
XM3 out net2 dvdd dvdd pfet_03v3 L=0.28u W=44.16u nf=32 ad='int((nf+1)/2) * W/nf * 0.18u' as='int((nf+2)/2) * W/nf * 0.18u' pd='2*int((nf+1)/2) * (W/nf + 0.18u)'
+ ps='2*int((nf+2)/2) * (W/nf + 0.18u)' nrd='0.18u / W' nrs='0.18u / W' sa=0 sb=0 sd=0 m=1 par=1
XM4 out net2 dvss dvss nfet_03v3 L=0.28u W=32.0u nf=32 ad='int((nf+1)/2) * W/nf * 0.18u' as='int((nf+2)/2) * W/nf * 0.18u' pd='2*int((nf+1)/2) * (W/nf + 0.18u)'
+ ps='2*int((nf+2)/2) * (W/nf + 0.18u)' nrd='0.18u / W' nrs='0.18u / W' sa=0 sb=0 sd=0 m=1 par=1
.ends

* expanding   symbol:  gate_drive_large.sym # of pins=5
** sym_path: /home/tim/gits/gf180mcu_ocd_chipalooza/dependencies/gf180mcu_ocd_ip__analog_switches/xschem/gate_drive_large.sym
** sch_path: /home/tim/gits/gf180mcu_ocd_chipalooza/dependencies/gf180mcu_ocd_ip__analog_switches/xschem/gate_drive_large.sch
.subckt gate_drive_large in_n in_p out vdd vss
*.PININFO in_n:I in_p:I vdd:I vss:I out:O
XM13 net1 S1_N vdd vdd pfet_05v0 L=0.50u W=1.0u nf=1 ad='int((nf+1)/2) * W/nf * 0.18u' as='int((nf+2)/2) * W/nf * 0.18u' pd='2*int((nf+1)/2) * (W/nf + 0.18u)'
+ ps='2*int((nf+2)/2) * (W/nf + 0.18u)' nrd='0.18u / W' nrs='0.18u / W' sa=0 sb=0 sd=0 m=2 par=2
XM14 net1 in_p vss vss nfet_05v0 L=0.60u W=2.0u nf=1 ad='int((nf+1)/2) * W/nf * 0.18u' as='int((nf+2)/2) * W/nf * 0.18u' pd='2*int((nf+1)/2) * (W/nf + 0.18u)'
+ ps='2*int((nf+2)/2) * (W/nf + 0.18u)' nrd='0.18u / W' nrs='0.18u / W' sa=0 sb=0 sd=0 m=2 par=2
XM15 S1_N net1 vdd vdd pfet_05v0 L=0.50u W=1.0u nf=1 ad='int((nf+1)/2) * W/nf * 0.18u' as='int((nf+2)/2) * W/nf * 0.18u' pd='2*int((nf+1)/2) * (W/nf + 0.18u)'
+ ps='2*int((nf+2)/2) * (W/nf + 0.18u)' nrd='0.18u / W' nrs='0.18u / W' sa=0 sb=0 sd=0 m=2 par=2
XM20 out S4_N vss vss nfet_05v0 L=0.60u W=5.0u nf=1 ad='int((nf+1)/2) * W/nf * 0.18u' as='int((nf+2)/2) * W/nf * 0.18u' pd='2*int((nf+1)/2) * (W/nf + 0.18u)'
+ ps='2*int((nf+2)/2) * (W/nf + 0.18u)' nrd='0.18u / W' nrs='0.18u / W' sa=0 sb=0 sd=0 m=60 par=60
XM21 S4_N S3_N vss vss nfet_05v0 L=0.60u W=5.0u nf=1 ad='int((nf+1)/2) * W/nf * 0.18u' as='int((nf+2)/2) * W/nf * 0.18u' pd='2*int((nf+1)/2) * (W/nf + 0.18u)'
+ ps='2*int((nf+2)/2) * (W/nf + 0.18u)' nrd='0.18u / W' nrs='0.18u / W' sa=0 sb=0 sd=0 m=20 par=20
XM22 S3_N S2_N vss vss nfet_05v0 L=0.60u W=5.0u nf=1 ad='int((nf+1)/2) * W/nf * 0.18u' as='int((nf+2)/2) * W/nf * 0.18u' pd='2*int((nf+1)/2) * (W/nf + 0.18u)'
+ ps='2*int((nf+2)/2) * (W/nf + 0.18u)' nrd='0.18u / W' nrs='0.18u / W' sa=0 sb=0 sd=0 m=6 par=6
XM23 S2_N S1_N vss vss nfet_05v0 L=0.60u W=5.0u nf=1 ad='int((nf+1)/2) * W/nf * 0.18u' as='int((nf+2)/2) * W/nf * 0.18u' pd='2*int((nf+1)/2) * (W/nf + 0.18u)'
+ ps='2*int((nf+2)/2) * (W/nf + 0.18u)' nrd='0.18u / W' nrs='0.18u / W' sa=0 sb=0 sd=0 m=2 par=2
XM24 S1_N in_n vss vss nfet_05v0 L=0.60u W=2.0u nf=1 ad='int((nf+1)/2) * W/nf * 0.18u' as='int((nf+2)/2) * W/nf * 0.18u' pd='2*int((nf+1)/2) * (W/nf + 0.18u)'
+ ps='2*int((nf+2)/2) * (W/nf + 0.18u)' nrd='0.18u / W' nrs='0.18u / W' sa=0 sb=0 sd=0 m=2 par=2
XM1 S2_N S1_N vdd vdd pfet_06v0 L=0.6u W=10.0u nf=1 ad='int((nf+1)/2) * W/nf * 0.18u' as='int((nf+2)/2) * W/nf * 0.18u' pd='2*int((nf+1)/2) * (W/nf + 0.18u)'
+ ps='2*int((nf+2)/2) * (W/nf + 0.18u)' nrd='0.18u / W' nrs='0.18u / W' sa=0 sb=0 sd=0 m=2 par=2
XM2 S3_N S2_N vdd vdd pfet_06v0 L=0.6u W=10.0u nf=1 ad='int((nf+1)/2) * W/nf * 0.18u' as='int((nf+2)/2) * W/nf * 0.18u' pd='2*int((nf+1)/2) * (W/nf + 0.18u)'
+ ps='2*int((nf+2)/2) * (W/nf + 0.18u)' nrd='0.18u / W' nrs='0.18u / W' sa=0 sb=0 sd=0 m=6 par=6
XM3 S4_N S3_N vdd vdd pfet_06v0 L=0.6u W=10.0u nf=1 ad='int((nf+1)/2) * W/nf * 0.18u' as='int((nf+2)/2) * W/nf * 0.18u' pd='2*int((nf+1)/2) * (W/nf + 0.18u)'
+ ps='2*int((nf+2)/2) * (W/nf + 0.18u)' nrd='0.18u / W' nrs='0.18u / W' sa=0 sb=0 sd=0 m=20 par=20
XM4 out S4_N vdd vdd pfet_06v0 L=0.6u W=10.0u nf=1 ad='int((nf+1)/2) * W/nf * 0.18u' as='int((nf+2)/2) * W/nf * 0.18u' pd='2*int((nf+1)/2) * (W/nf + 0.18u)'
+ ps='2*int((nf+2)/2) * (W/nf + 0.18u)' nrd='0.18u / W' nrs='0.18u / W' sa=0 sb=0 sd=0 m=60 par=60
.ends

* expanding   symbol:  por_amp.sym # of pins=7
** sym_path: /home/tim/gits/gf180mcu_ocd_chipalooza/dependencies/gf180mcu_ocd_ip__por/xschem/por_amp.sym
** sch_path: /home/tim/gits/gf180mcu_ocd_chipalooza/dependencies/gf180mcu_ocd_ip__por/xschem/por_amp.sch
.subckt por_amp vdd3v3 out inn inp ena vss nbias
*.PININFO ena:I inp:I inn:I out:O vdd3v3:B vss:B nbias:I
XM1 out net1 vdd3v3 vdd3v3 pfet_03v3 L=0.28u W=6u nf=6 ad='int((nf+1)/2) * W/nf * 0.18u' as='int((nf+2)/2) * W/nf * 0.18u' pd='2*int((nf+1)/2) * (W/nf + 0.18u)'
+ ps='2*int((nf+2)/2) * (W/nf + 0.18u)' nrd='0.18u / W' nrs='0.18u / W' sa=0 sb=0 sd=0 m=1 par=1
XM2 net1 net1 vdd3v3 vdd3v3 pfet_03v3 L=0.28u W=6u nf=6 ad='int((nf+1)/2) * W/nf * 0.18u' as='int((nf+2)/2) * W/nf * 0.18u' pd='2*int((nf+1)/2) * (W/nf + 0.18u)'
+ ps='2*int((nf+2)/2) * (W/nf + 0.18u)' nrd='0.18u / W' nrs='0.18u / W' sa=0 sb=0 sd=0 m=1 par=1
XM3 net1 inp nc vss nfet_03v3 L=0.28u W=12u nf=12 ad='int((nf+1)/2) * W/nf * 0.18u' as='int((nf+2)/2) * W/nf * 0.18u' pd='2*int((nf+1)/2) * (W/nf + 0.18u)'
+ ps='2*int((nf+2)/2) * (W/nf + 0.18u)' nrd='0.18u / W' nrs='0.18u / W' sa=0 sb=0 sd=0 m=1 par=1
XM4 out inn nc vss nfet_03v3 L=0.28u W=12u nf=12 ad='int((nf+1)/2) * W/nf * 0.18u' as='int((nf+2)/2) * W/nf * 0.18u' pd='2*int((nf+1)/2) * (W/nf + 0.18u)'
+ ps='2*int((nf+2)/2) * (W/nf + 0.18u)' nrd='0.18u / W' nrs='0.18u / W' sa=0 sb=0 sd=0 m=1 par=1
XM5 nc ena net2 vss nfet_03v3 L=0.28u W=12u nf=12 ad='int((nf+1)/2) * W/nf * 0.18u' as='int((nf+2)/2) * W/nf * 0.18u' pd='2*int((nf+1)/2) * (W/nf + 0.18u)'
+ ps='2*int((nf+2)/2) * (W/nf + 0.18u)' nrd='0.18u / W' nrs='0.18u / W' sa=0 sb=0 sd=0 m=1 par=1
XM6 net2 nbias vss vss nfet_03v3 L=0.28u W=12u nf=12 ad='int((nf+1)/2) * W/nf * 0.18u' as='int((nf+2)/2) * W/nf * 0.18u' pd='2*int((nf+1)/2) * (W/nf + 0.18u)'
+ ps='2*int((nf+2)/2) * (W/nf + 0.18u)' nrd='0.18u / W' nrs='0.18u / W' sa=0 sb=0 sd=0 m=1 par=1
XM7 vdd3v3 vdd3v3 vdd3v3 vdd3v3 pfet_03v3 L=0.28u W=4u nf=4 ad='int((nf+1)/2) * W/nf * 0.18u' as='int((nf+2)/2) * W/nf * 0.18u' pd='2*int((nf+1)/2) * (W/nf + 0.18u)'
+ ps='2*int((nf+2)/2) * (W/nf + 0.18u)' nrd='0.18u / W' nrs='0.18u / W' sa=0 sb=0 sd=0 m=1 par=1
XM8 vss vss vss vss nfet_03v3 L=0.28u W=2u nf=2 ad='int((nf+1)/2) * W/nf * 0.18u' as='int((nf+2)/2) * W/nf * 0.18u' pd='2*int((nf+1)/2) * (W/nf + 0.18u)'
+ ps='2*int((nf+2)/2) * (W/nf + 0.18u)' nrd='0.18u / W' nrs='0.18u / W' sa=0 sb=0 sd=0 m=1 par=1
XM9 nc vss vss vss nfet_03v3 L=0.28u W=2u nf=2 ad='int((nf+1)/2) * W/nf * 0.18u' as='int((nf+2)/2) * W/nf * 0.18u' pd='2*int((nf+1)/2) * (W/nf + 0.18u)'
+ ps='2*int((nf+2)/2) * (W/nf + 0.18u)' nrd='0.18u / W' nrs='0.18u / W' sa=0 sb=0 sd=0 m=1 par=1
.ends

* expanding   symbol:  por_3v3_schmitt_inv.sym # of pins=4
** sym_path: /home/tim/gits/gf180mcu_ocd_chipalooza/dependencies/gf180mcu_ocd_ip__por/xschem/por_3v3_schmitt_inv.sym
** sch_path: /home/tim/gits/gf180mcu_ocd_chipalooza/dependencies/gf180mcu_ocd_ip__por/xschem/por_3v3_schmitt_inv.sch
.subckt por_3v3_schmitt_inv vdd3v3 in out vss
*.PININFO vdd3v3:B vss:B in:I out:O
XM1 out in n1 vss nfet_03v3 L=0.28u W=1.5u nf=2 ad='int((nf+1)/2) * W/nf * 0.18u' as='int((nf+2)/2) * W/nf * 0.18u' pd='2*int((nf+1)/2) * (W/nf + 0.18u)'
+ ps='2*int((nf+2)/2) * (W/nf + 0.18u)' nrd='0.18u / W' nrs='0.18u / W' sa=0 sb=0 sd=0 m=1 par=1
XM2 out in p1 vdd3v3 pfet_03v3 L=0.28u W=0.75u nf=1 ad='int((nf+1)/2) * W/nf * 0.18u' as='int((nf+2)/2) * W/nf * 0.18u' pd='2*int((nf+1)/2) * (W/nf + 0.18u)'
+ ps='2*int((nf+2)/2) * (W/nf + 0.18u)' nrd='0.18u / W' nrs='0.18u / W' sa=0 sb=0 sd=0 m=1 par=1
XM3 p1 in vdd3v3 vdd3v3 pfet_03v3 L=0.28u W=3u nf=4 ad='int((nf+1)/2) * W/nf * 0.18u' as='int((nf+2)/2) * W/nf * 0.18u' pd='2*int((nf+1)/2) * (W/nf + 0.18u)'
+ ps='2*int((nf+2)/2) * (W/nf + 0.18u)' nrd='0.18u / W' nrs='0.18u / W' sa=0 sb=0 sd=0 m=1 par=1
XM4 n1 in vss vss nfet_03v3 L=0.28u W=1.5u nf=2 ad='int((nf+1)/2) * W/nf * 0.18u' as='int((nf+2)/2) * W/nf * 0.18u' pd='2*int((nf+1)/2) * (W/nf + 0.18u)'
+ ps='2*int((nf+2)/2) * (W/nf + 0.18u)' nrd='0.18u / W' nrs='0.18u / W' sa=0 sb=0 sd=0 m=1 par=1
XM5 n1 out vdd3v3 vss nfet_03v3 L=0.56u W=6u nf=1 ad='int((nf+1)/2) * W/nf * 0.18u' as='int((nf+2)/2) * W/nf * 0.18u' pd='2*int((nf+1)/2) * (W/nf + 0.18u)'
+ ps='2*int((nf+2)/2) * (W/nf + 0.18u)' nrd='0.18u / W' nrs='0.18u / W' sa=0 sb=0 sd=0 m=1 par=1
XM6 p1 out vss vdd3v3 pfet_03v3 L=0.56u W=3u nf=1 ad='int((nf+1)/2) * W/nf * 0.18u' as='int((nf+2)/2) * W/nf * 0.18u' pd='2*int((nf+1)/2) * (W/nf + 0.18u)'
+ ps='2*int((nf+2)/2) * (W/nf + 0.18u)' nrd='0.18u / W' nrs='0.18u / W' sa=0 sb=0 sd=0 m=1 par=1
.ends

* expanding   symbol:  xgate.sym # of pins=6
** sym_path: /home/tim/gits/gf180mcu_ocd_chipalooza/dependencies/gf180mcu_ocd_ip__biasgen/xschem/xgate.sym
** sch_path: /home/tim/gits/gf180mcu_ocd_chipalooza/dependencies/gf180mcu_ocd_ip__biasgen/xschem/xgate.sch
.subckt xgate ena_b vdd in out vss ena
*.PININFO out:B in:B vdd:B vss:B ena_b:I ena:I
XM3 in ena out vss nfet_05v0 L=0.60u W=2.0u nf=1 ad='int((nf+1)/2) * W/nf * 0.18u' as='int((nf+2)/2) * W/nf * 0.18u' pd='2*int((nf+1)/2) * (W/nf + 0.18u)'
+ ps='2*int((nf+2)/2) * (W/nf + 0.18u)' nrd='0.18u / W' nrs='0.18u / W' sa=0 sb=0 sd=0 m=1 par=1
XM4 in ena_b out vdd pfet_05v0 L=0.50u W=2.0u nf=1 ad='int((nf+1)/2) * W/nf * 0.18u' as='int((nf+2)/2) * W/nf * 0.18u' pd='2*int((nf+1)/2) * (W/nf + 0.18u)'
+ ps='2*int((nf+2)/2) * (W/nf + 0.18u)' nrd='0.18u / W' nrs='0.18u / W' sa=0 sb=0 sd=0 m=1 par=1
.ends

* expanding   symbol:  hv_inv_1.sym # of pins=4
** sym_path: /home/tim/gits/gf180mcu_ocd_chipalooza/dependencies/gf180mcu_ocd_ip__biasgen/xschem/hv_inv_1.sym
** sch_path: /home/tim/gits/gf180mcu_ocd_chipalooza/dependencies/gf180mcu_ocd_ip__biasgen/xschem/hv_inv_1.sch
.subckt hv_inv_1 vdd A X vss
*.PININFO A:I vdd:B vss:B X:O
XM3 X A vdd vdd pfet_05v0 L=0.50u W=2.00u nf=1 ad='int((nf+1)/2) * W/nf * 0.18u' as='int((nf+2)/2) * W/nf * 0.18u' pd='2*int((nf+1)/2) * (W/nf + 0.18u)'
+ ps='2*int((nf+2)/2) * (W/nf + 0.18u)' nrd='0.18u / W' nrs='0.18u / W' sa=0 sb=0 sd=0 m=1 par=1
XM4 X A vss vss nfet_05v0 L=0.60u W=1.00u nf=1 ad='int((nf+1)/2) * W/nf * 0.18u' as='int((nf+2)/2) * W/nf * 0.18u' pd='2*int((nf+1)/2) * (W/nf + 0.18u)'
+ ps='2*int((nf+2)/2) * (W/nf + 0.18u)' nrd='0.18u / W' nrs='0.18u / W' sa=0 sb=0 sd=0 m=1 par=1
.ends

* expanding   symbol:  level_shift_5v.sym # of pins=3
** sym_path: /home/tim/gits/gf180mcu_ocd_chipalooza/dependencies/gf180mcu_ocd_ip__biasgen/xschem/level_shift_5v.sym
** sch_path: /home/tim/gits/gf180mcu_ocd_chipalooza/dependencies/gf180mcu_ocd_ip__biasgen/xschem/level_shift_5v.sch
.subckt level_shift_5v in_n in_p out vdd vss
*.PININFO in_n:I in_p:I out:O
XM8 net1 in_p vss vss nfet_05v0 L=0.6u W=4.0u nf=1 ad='int((nf+1)/2) * W/nf * 0.18u' as='int((nf+2)/2) * W/nf * 0.18u' pd='2*int((nf+1)/2) * (W/nf + 0.18u)'
+ ps='2*int((nf+2)/2) * (W/nf + 0.18u)' nrd='0.18u / W' nrs='0.18u / W' sa=0 sb=0 sd=0 m=2 par=2
XM10 net1 S1_N vdd vdd pfet_05v0 L=0.5u W=1.0u nf=1 ad='int((nf+1)/2) * W/nf * 0.18u' as='int((nf+2)/2) * W/nf * 0.18u' pd='2*int((nf+1)/2) * (W/nf + 0.18u)'
+ ps='2*int((nf+2)/2) * (W/nf + 0.18u)' nrd='0.18u / W' nrs='0.18u / W' sa=0 sb=0 sd=0 m=2 par=2
XM2 out S2_N vdd vdd pfet_05v0 L=0.5u W=2.0u nf=1 ad='int((nf+1)/2) * W/nf * 0.18u' as='int((nf+2)/2) * W/nf * 0.18u' pd='2*int((nf+1)/2) * (W/nf + 0.18u)'
+ ps='2*int((nf+2)/2) * (W/nf + 0.18u)' nrd='0.18u / W' nrs='0.18u / W' sa=0 sb=0 sd=0 m=4 par=4
XM9 S1_N net1 vdd vdd pfet_05v0 L=0.5u W=1.0u nf=1 ad='int((nf+1)/2) * W/nf * 0.18u' as='int((nf+2)/2) * W/nf * 0.18u' pd='2*int((nf+1)/2) * (W/nf + 0.18u)'
+ ps='2*int((nf+2)/2) * (W/nf + 0.18u)' nrd='0.18u / W' nrs='0.18u / W' sa=0 sb=0 sd=0 m=2 par=2
XM4 S2_N S1_N vdd vdd pfet_05v0 L=0.5u W=2.0u nf=1 ad='int((nf+1)/2) * W/nf * 0.18u' as='int((nf+2)/2) * W/nf * 0.18u' pd='2*int((nf+1)/2) * (W/nf + 0.18u)'
+ ps='2*int((nf+2)/2) * (W/nf + 0.18u)' nrd='0.18u / W' nrs='0.18u / W' sa=0 sb=0 sd=0 m=2 par=2
XM1 S1_N in_n vss vss nfet_05v0 L=0.6u W=4.0u nf=1 ad='int((nf+1)/2) * W/nf * 0.18u' as='int((nf+2)/2) * W/nf * 0.18u' pd='2*int((nf+1)/2) * (W/nf + 0.18u)'
+ ps='2*int((nf+2)/2) * (W/nf + 0.18u)' nrd='0.18u / W' nrs='0.18u / W' sa=0 sb=0 sd=0 m=2 par=2
XM3 S2_N S1_N vss vss nfet_05v0 L=0.6u W=1.0u nf=1 ad='int((nf+1)/2) * W/nf * 0.18u' as='int((nf+2)/2) * W/nf * 0.18u' pd='2*int((nf+1)/2) * (W/nf + 0.18u)'
+ ps='2*int((nf+2)/2) * (W/nf + 0.18u)' nrd='0.18u / W' nrs='0.18u / W' sa=0 sb=0 sd=0 m=2 par=2
XM5 out S2_N vss vss nfet_05v0 L=0.6u W=1.0u nf=1 ad='int((nf+1)/2) * W/nf * 0.18u' as='int((nf+2)/2) * W/nf * 0.18u' pd='2*int((nf+1)/2) * (W/nf + 0.18u)'
+ ps='2*int((nf+2)/2) * (W/nf + 0.18u)' nrd='0.18u / W' nrs='0.18u / W' sa=0 sb=0 sd=0 m=4 par=4
.ends

* expanding   symbol:  n_amp_large.sym # of pins=7
** sym_path: /home/tim/gits/gf180mcu_ocd_chipalooza/dependencies/gf180mcu_ocd_ip__biasgen/xschem/n_amp_large.sym
** sch_path: /home/tim/gits/gf180mcu_ocd_chipalooza/dependencies/gf180mcu_ocd_ip__biasgen/xschem/n_amp_large.sch
.subckt n_amp_large avdd out inn inp ibias avss ena
*.PININFO inp:I inn:I out:O avdd:B avss:B ena:I ibias:B
XM9 out outn avdd avdd pfet_05v0 L=0.50u W=10.0u nf=10 ad='int((nf+1)/2) * W/nf * 0.18u' as='int((nf+2)/2) * W/nf * 0.18u' pd='2*int((nf+1)/2) * (W/nf + 0.18u)'
+ ps='2*int((nf+2)/2) * (W/nf + 0.18u)' nrd='0.18u / W' nrs='0.18u / W' sa=0 sb=0 sd=0 m=1 par=1
XM10 vcom net1 avss avss nfet_05v0 L=0.60u W=20.0u nf=20 ad='int((nf+1)/2) * W/nf * 0.18u' as='int((nf+2)/2) * W/nf * 0.18u' pd='2*int((nf+1)/2) * (W/nf + 0.18u)'
+ ps='2*int((nf+2)/2) * (W/nf + 0.18u)' nrd='0.18u / W' nrs='0.18u / W' sa=0 sb=0 sd=0 m=1 par=1
XM1 ibias ena net1 avss nfet_05v0 L=0.60u W=20.0u nf=20 ad='int((nf+1)/2) * W/nf * 0.18u' as='int((nf+2)/2) * W/nf * 0.18u' pd='2*int((nf+1)/2) * (W/nf + 0.18u)'
+ ps='2*int((nf+2)/2) * (W/nf + 0.18u)' nrd='0.18u / W' nrs='0.18u / W' sa=0 sb=0 sd=0 m=1 par=1
XM6 net1 net1 avss avss nfet_05v0 L=0.60u W=20.0u nf=20 ad='int((nf+1)/2) * W/nf * 0.18u' as='int((nf+2)/2) * W/nf * 0.18u' pd='2*int((nf+1)/2) * (W/nf + 0.18u)'
+ ps='2*int((nf+2)/2) * (W/nf + 0.18u)' nrd='0.18u / W' nrs='0.18u / W' sa=0 sb=0 sd=0 m=1 par=1
XM4 outn inp vcom avss nfet_05v0 L=0.60u W=20.0u nf=20 ad='int((nf+1)/2) * W/nf * 0.18u' as='int((nf+2)/2) * W/nf * 0.18u' pd='2*int((nf+1)/2) * (W/nf + 0.18u)'
+ ps='2*int((nf+2)/2) * (W/nf + 0.18u)' nrd='0.18u / W' nrs='0.18u / W' sa=0 sb=0 sd=0 m=1 par=1
XM5 out inn vcom avss nfet_05v0 L=0.60u W=20.0u nf=20 ad='int((nf+1)/2) * W/nf * 0.18u' as='int((nf+2)/2) * W/nf * 0.18u' pd='2*int((nf+1)/2) * (W/nf + 0.18u)'
+ ps='2*int((nf+2)/2) * (W/nf + 0.18u)' nrd='0.18u / W' nrs='0.18u / W' sa=0 sb=0 sd=0 m=1 par=1
XM2 outn outn avdd avdd pfet_05v0 L=0.50u W=10.0u nf=10 ad='int((nf+1)/2) * W/nf * 0.18u' as='int((nf+2)/2) * W/nf * 0.18u' pd='2*int((nf+1)/2) * (W/nf + 0.18u)'
+ ps='2*int((nf+2)/2) * (W/nf + 0.18u)' nrd='0.18u / W' nrs='0.18u / W' sa=0 sb=0 sd=0 m=1 par=1
XM3 avdd avdd avdd avdd pfet_05v0 L=0.50u W=1.0u nf=1 ad='int((nf+1)/2) * W/nf * 0.18u' as='int((nf+2)/2) * W/nf * 0.18u' pd='2*int((nf+1)/2) * (W/nf + 0.18u)'
+ ps='2*int((nf+2)/2) * (W/nf + 0.18u)' nrd='0.18u / W' nrs='0.18u / W' sa=0 sb=0 sd=0 m=6 par=6
XM7 avss avss avss avss nfet_05v0 L=0.60u W=8.0u nf=8 ad='int((nf+1)/2) * W/nf * 0.18u' as='int((nf+2)/2) * W/nf * 0.18u' pd='2*int((nf+1)/2) * (W/nf + 0.18u)'
+ ps='2*int((nf+2)/2) * (W/nf + 0.18u)' nrd='0.18u / W' nrs='0.18u / W' sa=0 sb=0 sd=0 m=1 par=1
.ends

* expanding   symbol:  se_folded_cascode_p_5v.sym # of pins=7
** sym_path: /home/tim/gits/gf180mcu_ocd_chipalooza/dependencies/gf180mcu_ocd_ip__biasgen/xschem/se_folded_cascode_p_5v.sym
** sch_path: /home/tim/gits/gf180mcu_ocd_chipalooza/dependencies/gf180mcu_ocd_ip__biasgen/xschem/se_folded_cascode_p_5v.sch
.subckt se_folded_cascode_p_5v vdd out inp inn vss bias ena
*.PININFO inn:I inp:I out:O bias:B vdd:B vss:B ena:I
XM16 vbn2 vbn2 vbn1 vss nfet_05v0 L=4.0u W=1.0u nf=1 ad='int((nf+1)/2) * W/nf * 0.18u' as='int((nf+2)/2) * W/nf * 0.18u' pd='2*int((nf+1)/2) * (W/nf + 0.18u)'
+ ps='2*int((nf+2)/2) * (W/nf + 0.18u)' nrd='0.18u / W' nrs='0.18u / W' sa=0 sb=0 sd=0 m=4 par=4
XM22 vbp1 vbp1 vdd vdd pfet_05v0 L=1.0u W=1.0u nf=1 ad='int((nf+1)/2) * W/nf * 0.18u' as='int((nf+2)/2) * W/nf * 0.18u' pd='2*int((nf+1)/2) * (W/nf + 0.18u)'
+ ps='2*int((nf+2)/2) * (W/nf + 0.18u)' nrd='0.18u / W' nrs='0.18u / W' sa=0 sb=0 sd=0 m=4 par=4
XM23 vbn2 vbp1 vdd vdd pfet_05v0 L=1.0u W=1.0u nf=1 ad='int((nf+1)/2) * W/nf * 0.18u' as='int((nf+2)/2) * W/nf * 0.18u' pd='2*int((nf+1)/2) * (W/nf + 0.18u)'
+ ps='2*int((nf+2)/2) * (W/nf + 0.18u)' nrd='0.18u / W' nrs='0.18u / W' sa=0 sb=0 sd=0 m=4 par=4
XM24 bias ena vdd vdd pfet_05v0 L=0.5u W=1.0u nf=1 ad='int((nf+1)/2) * W/nf * 0.18u' as='int((nf+2)/2) * W/nf * 0.18u' pd='2*int((nf+1)/2) * (W/nf + 0.18u)'
+ ps='2*int((nf+2)/2) * (W/nf + 0.18u)' nrd='0.18u / W' nrs='0.18u / W' sa=0 sb=0 sd=0 m=1 par=1
XM25 diff vbp1 vdd vdd pfet_05v0 L=1.0u W=1.0u nf=1 ad='int((nf+1)/2) * W/nf * 0.18u' as='int((nf+2)/2) * W/nf * 0.18u' pd='2*int((nf+1)/2) * (W/nf + 0.18u)'
+ ps='2*int((nf+2)/2) * (W/nf + 0.18u)' nrd='0.18u / W' nrs='0.18u / W' sa=0 sb=0 sd=0 m=16 par=16
XM26 out1n inp diff vdd pfet_05v0 L=1.0u W=4.0u nf=1 ad='int((nf+1)/2) * W/nf * 0.18u' as='int((nf+2)/2) * W/nf * 0.18u' pd='2*int((nf+1)/2) * (W/nf + 0.18u)'
+ ps='2*int((nf+2)/2) * (W/nf + 0.18u)' nrd='0.18u / W' nrs='0.18u / W' sa=0 sb=0 sd=0 m=8 par=8
XM27 out1p inn diff vdd pfet_05v0 L=1.0u W=4.0u nf=1 ad='int((nf+1)/2) * W/nf * 0.18u' as='int((nf+2)/2) * W/nf * 0.18u' pd='2*int((nf+1)/2) * (W/nf + 0.18u)'
+ ps='2*int((nf+2)/2) * (W/nf + 0.18u)' nrd='0.18u / W' nrs='0.18u / W' sa=0 sb=0 sd=0 m=8 par=8
XM28 nd10 mirr vdd vdd pfet_05v0 L=4.0u W=2.0u nf=1 ad='int((nf+1)/2) * W/nf * 0.18u' as='int((nf+2)/2) * W/nf * 0.18u' pd='2*int((nf+1)/2) * (W/nf + 0.18u)'
+ ps='2*int((nf+2)/2) * (W/nf + 0.18u)' nrd='0.18u / W' nrs='0.18u / W' sa=0 sb=0 sd=0 m=8 par=8
XM29 nd11 mirr vdd vdd pfet_05v0 L=4.0u W=2.0u nf=1 ad='int((nf+1)/2) * W/nf * 0.18u' as='int((nf+2)/2) * W/nf * 0.18u' pd='2*int((nf+1)/2) * (W/nf + 0.18u)'
+ ps='2*int((nf+2)/2) * (W/nf + 0.18u)' nrd='0.18u / W' nrs='0.18u / W' sa=0 sb=0 sd=0 m=8 par=8
XM30 out bias nd11 vdd pfet_05v0 L=0.5u W=2.0u nf=1 ad='int((nf+1)/2) * W/nf * 0.18u' as='int((nf+2)/2) * W/nf * 0.18u' pd='2*int((nf+1)/2) * (W/nf + 0.18u)'
+ ps='2*int((nf+2)/2) * (W/nf + 0.18u)' nrd='0.18u / W' nrs='0.18u / W' sa=0 sb=0 sd=0 m=16 par=16
XM31 mirr bias nd10 vdd pfet_05v0 L=0.5u W=2.0u nf=1 ad='int((nf+1)/2) * W/nf * 0.18u' as='int((nf+2)/2) * W/nf * 0.18u' pd='2*int((nf+1)/2) * (W/nf + 0.18u)'
+ ps='2*int((nf+2)/2) * (W/nf + 0.18u)' nrd='0.18u / W' nrs='0.18u / W' sa=0 sb=0 sd=0 m=16 par=16
XM1 bias bias vbp1 vdd pfet_05v0 L=0.5u W=2.0u nf=1 ad='int((nf+1)/2) * W/nf * 0.18u' as='int((nf+2)/2) * W/nf * 0.18u' pd='2*int((nf+1)/2) * (W/nf + 0.18u)'
+ ps='2*int((nf+2)/2) * (W/nf + 0.18u)' nrd='0.18u / W' nrs='0.18u / W' sa=0 sb=0 sd=0 m=8 par=8
XM2 vbn1 vbn1 vss vss nfet_05v0 L=1.0u W=1.0u nf=1 ad='int((nf+1)/2) * W/nf * 0.18u' as='int((nf+2)/2) * W/nf * 0.18u' pd='2*int((nf+1)/2) * (W/nf + 0.18u)'
+ ps='2*int((nf+2)/2) * (W/nf + 0.18u)' nrd='0.18u / W' nrs='0.18u / W' sa=0 sb=0 sd=0 m=4 par=4
XM3 out1p vbn1 vss vss nfet_05v0 L=1.0u W=1.0u nf=1 ad='int((nf+1)/2) * W/nf * 0.18u' as='int((nf+2)/2) * W/nf * 0.18u' pd='2*int((nf+1)/2) * (W/nf + 0.18u)'
+ ps='2*int((nf+2)/2) * (W/nf + 0.18u)' nrd='0.18u / W' nrs='0.18u / W' sa=0 sb=0 sd=0 m=16 par=16
XM5 out1n vbn1 vss vss nfet_05v0 L=1.0u W=1.0u nf=1 ad='int((nf+1)/2) * W/nf * 0.18u' as='int((nf+2)/2) * W/nf * 0.18u' pd='2*int((nf+1)/2) * (W/nf + 0.18u)'
+ ps='2*int((nf+2)/2) * (W/nf + 0.18u)' nrd='0.18u / W' nrs='0.18u / W' sa=0 sb=0 sd=0 m=16 par=16
XM6 mirr vbn2 out1n vss nfet_05v0 L=4.0u W=1.0u nf=1 ad='int((nf+1)/2) * W/nf * 0.18u' as='int((nf+2)/2) * W/nf * 0.18u' pd='2*int((nf+1)/2) * (W/nf + 0.18u)'
+ ps='2*int((nf+2)/2) * (W/nf + 0.18u)' nrd='0.18u / W' nrs='0.18u / W' sa=0 sb=0 sd=0 m=8 par=8
XM4 out vbn2 out1p vss nfet_05v0 L=4.0u W=1.0u nf=1 ad='int((nf+1)/2) * W/nf * 0.18u' as='int((nf+2)/2) * W/nf * 0.18u' pd='2*int((nf+1)/2) * (W/nf + 0.18u)'
+ ps='2*int((nf+2)/2) * (W/nf + 0.18u)' nrd='0.18u / W' nrs='0.18u / W' sa=0 sb=0 sd=0 m=8 par=8
XM7 vss vss vss vss nfet_05v0 L=1.0u W=1.0u nf=1 ad='int((nf+1)/2) * W/nf * 0.18u' as='int((nf+2)/2) * W/nf * 0.18u' pd='2*int((nf+1)/2) * (W/nf + 0.18u)'
+ ps='2*int((nf+2)/2) * (W/nf + 0.18u)' nrd='0.18u / W' nrs='0.18u / W' sa=0 sb=0 sd=0 m=14 par=14
XM8 vdd vdd vdd vdd pfet_05v0 L=1.0u W=4.0u nf=1 ad='int((nf+1)/2) * W/nf * 0.18u' as='int((nf+2)/2) * W/nf * 0.18u' pd='2*int((nf+1)/2) * (W/nf + 0.18u)'
+ ps='2*int((nf+2)/2) * (W/nf + 0.18u)' nrd='0.18u / W' nrs='0.18u / W' sa=0 sb=0 sd=0 m=8 par=8
XM10 vdd vdd vdd vdd pfet_05v0 L=4.0u W=2.0u nf=1 ad='int((nf+1)/2) * W/nf * 0.18u' as='int((nf+2)/2) * W/nf * 0.18u' pd='2*int((nf+1)/2) * (W/nf + 0.18u)'
+ ps='2*int((nf+2)/2) * (W/nf + 0.18u)' nrd='0.18u / W' nrs='0.18u / W' sa=0 sb=0 sd=0 m=4 par=4
XM11 vss vss vss vss nfet_05v0 L=2.0u W=1.0u nf=1 ad='int((nf+1)/2) * W/nf * 0.18u' as='int((nf+2)/2) * W/nf * 0.18u' pd='2*int((nf+1)/2) * (W/nf + 0.18u)'
+ ps='2*int((nf+2)/2) * (W/nf + 0.18u)' nrd='0.18u / W' nrs='0.18u / W' sa=0 sb=0 sd=0 m=2 par=2
.ends

* expanding   symbol:  se_folded_cascode_np_ab.sym # of pins=7
** sym_path: /home/tim/gits/gf180mcu_ocd_chipalooza/dependencies/gf180mcu_ocd_ip__biasgen/xschem/se_folded_cascode_np_ab.sym
** sch_path: /home/tim/gits/gf180mcu_ocd_chipalooza/dependencies/gf180mcu_ocd_ip__biasgen/xschem/se_folded_cascode_np_ab.sch
.subckt se_folded_cascode_np_ab vdd out inp inn vss bias ena
*.PININFO vdd:B bias:B inp:I inn:I vss:B out:O ena:I
XC2 out outs1 cap_mim_2f0_m4m5_noshield c_width=12.0e-6 c_length=19.0e-6 m=3
XM1 vbn2 vbp1 vdd vdd pfet_03v3 L=1.0u W=1.0u nf=1 ad='int((nf+1)/2) * W/nf * 0.18u' as='int((nf+2)/2) * W/nf * 0.18u' pd='2*int((nf+1)/2) * (W/nf + 0.18u)'
+ ps='2*int((nf+2)/2) * (W/nf + 0.18u)' nrd='0.18u / W' nrs='0.18u / W' sa=0 sb=0 sd=0 m=4 par=4
XM3 bias bias vbp1 vdd pfet_03v3 L=0.5u W=1.0u nf=1 ad='int((nf+1)/2) * W/nf * 0.18u' as='int((nf+2)/2) * W/nf * 0.18u' pd='2*int((nf+1)/2) * (W/nf + 0.18u)'
+ ps='2*int((nf+2)/2) * (W/nf + 0.18u)' nrd='0.18u / W' nrs='0.18u / W' sa=0 sb=0 sd=0 m=12 par=12
XM12 diffb vbp1 vdd vdd pfet_03v3 L=1.0u W=1.0u nf=1 ad='int((nf+1)/2) * W/nf * 0.18u' as='int((nf+2)/2) * W/nf * 0.18u' pd='2*int((nf+1)/2) * (W/nf + 0.18u)'
+ ps='2*int((nf+2)/2) * (W/nf + 0.18u)' nrd='0.18u / W' nrs='0.18u / W' sa=0 sb=0 sd=0 m=16 par=16
XM13 outb1n inn diffb vdd pfet_03v3 L=1u W=4u nf=1 ad='int((nf+1)/2) * W/nf * 0.18u' as='int((nf+2)/2) * W/nf * 0.18u' pd='2*int((nf+1)/2) * (W/nf + 0.18u)'
+ ps='2*int((nf+2)/2) * (W/nf + 0.18u)' nrd='0.18u / W' nrs='0.18u / W' sa=0 sb=0 sd=0 m=8 par=8
XM16 outa1n outa1n vdd vdd pfet_03v3 L=1u W=1u nf=1 ad='int((nf+1)/2) * W/nf * 0.18u' as='int((nf+2)/2) * W/nf * 0.18u' pd='2*int((nf+1)/2) * (W/nf + 0.18u)'
+ ps='2*int((nf+2)/2) * (W/nf + 0.18u)' nrd='0.18u / W' nrs='0.18u / W' sa=0 sb=0 sd=0 m=12 par=12
XM17 out outs1 vdd vdd pfet_03v3 L=4u W=4u nf=1 ad='int((nf+1)/2) * W/nf * 0.18u' as='int((nf+2)/2) * W/nf * 0.18u' pd='2*int((nf+1)/2) * (W/nf + 0.18u)'
+ ps='2*int((nf+2)/2) * (W/nf + 0.18u)' nrd='0.18u / W' nrs='0.18u / W' sa=0 sb=0 sd=0 m=4 par=4
XM18 vbp1 vbp1 vdd vdd pfet_03v3 L=1.0u W=1.0u nf=1 ad='int((nf+1)/2) * W/nf * 0.18u' as='int((nf+2)/2) * W/nf * 0.18u' pd='2*int((nf+1)/2) * (W/nf + 0.18u)'
+ ps='2*int((nf+2)/2) * (W/nf + 0.18u)' nrd='0.18u / W' nrs='0.18u / W' sa=0 sb=0 sd=0 m=4 par=4
XM15 outa1p outa1n vdd vdd pfet_03v3 L=1u W=1u nf=1 ad='int((nf+1)/2) * W/nf * 0.18u' as='int((nf+2)/2) * W/nf * 0.18u' pd='2*int((nf+1)/2) * (W/nf + 0.18u)'
+ ps='2*int((nf+2)/2) * (W/nf + 0.18u)' nrd='0.18u / W' nrs='0.18u / W' sa=0 sb=0 sd=0 m=12 par=12
XM4 mirr mirr outa1n vdd pfet_03v3 L=4.0u W=1.0u nf=1 ad='int((nf+1)/2) * W/nf * 0.18u' as='int((nf+2)/2) * W/nf * 0.18u' pd='2*int((nf+1)/2) * (W/nf + 0.18u)'
+ ps='2*int((nf+2)/2) * (W/nf + 0.18u)' nrd='0.18u / W' nrs='0.18u / W' sa=0 sb=0 sd=0 m=16 par=16
XM5 outs1 mirr outa1p vdd pfet_03v3 L=4.0u W=1.0u nf=1 ad='int((nf+1)/2) * W/nf * 0.18u' as='int((nf+2)/2) * W/nf * 0.18u' pd='2*int((nf+1)/2) * (W/nf + 0.18u)'
+ ps='2*int((nf+2)/2) * (W/nf + 0.18u)' nrd='0.18u / W' nrs='0.18u / W' sa=0 sb=0 sd=0 m=16 par=16
XM6 outb1p inp diffb vdd pfet_03v3 L=1u W=4u nf=1 ad='int((nf+1)/2) * W/nf * 0.18u' as='int((nf+2)/2) * W/nf * 0.18u' pd='2*int((nf+1)/2) * (W/nf + 0.18u)'
+ ps='2*int((nf+2)/2) * (W/nf + 0.18u)' nrd='0.18u / W' nrs='0.18u / W' sa=0 sb=0 sd=0 m=8 par=8
XM7 vbn2 vbn2 vbn1 vss nfet_03v3 L=4u W=2u nf=1 ad='int((nf+1)/2) * W/nf * 0.18u' as='int((nf+2)/2) * W/nf * 0.18u' pd='2*int((nf+1)/2) * (W/nf + 0.18u)'
+ ps='2*int((nf+2)/2) * (W/nf + 0.18u)' nrd='0.18u / W' nrs='0.18u / W' sa=0 sb=0 sd=0 m=4 par=4
XM19 vbn1 vbn1 vss vss nfet_03v3 L=1u W=1u nf=1 ad='int((nf+1)/2) * W/nf * 0.18u' as='int((nf+2)/2) * W/nf * 0.18u' pd='2*int((nf+1)/2) * (W/nf + 0.18u)'
+ ps='2*int((nf+2)/2) * (W/nf + 0.18u)' nrd='0.18u / W' nrs='0.18u / W' sa=0 sb=0 sd=0 m=4 par=4
XM20 outa1n inn diffa vss nfet_03v3 L=1u W=2u nf=1 ad='int((nf+1)/2) * W/nf * 0.18u' as='int((nf+2)/2) * W/nf * 0.18u' pd='2*int((nf+1)/2) * (W/nf + 0.18u)'
+ ps='2*int((nf+2)/2) * (W/nf + 0.18u)' nrd='0.18u / W' nrs='0.18u / W' sa=0 sb=0 sd=0 m=8 par=8
XM21 outa1p inp diffa vss nfet_03v3 L=1u W=2u nf=1 ad='int((nf+1)/2) * W/nf * 0.18u' as='int((nf+2)/2) * W/nf * 0.18u' pd='2*int((nf+1)/2) * (W/nf + 0.18u)'
+ ps='2*int((nf+2)/2) * (W/nf + 0.18u)' nrd='0.18u / W' nrs='0.18u / W' sa=0 sb=0 sd=0 m=8 par=8
XM22 diffa vbn1 vss vss nfet_03v3 L=1u W=1u nf=1 ad='int((nf+1)/2) * W/nf * 0.18u' as='int((nf+2)/2) * W/nf * 0.18u' pd='2*int((nf+1)/2) * (W/nf + 0.18u)'
+ ps='2*int((nf+2)/2) * (W/nf + 0.18u)' nrd='0.18u / W' nrs='0.18u / W' sa=0 sb=0 sd=0 m=8 par=8
XM14 outb1n vbn1 vss vss nfet_03v3 L=1u W=1u nf=1 ad='int((nf+1)/2) * W/nf * 0.18u' as='int((nf+2)/2) * W/nf * 0.18u' pd='2*int((nf+1)/2) * (W/nf + 0.18u)'
+ ps='2*int((nf+2)/2) * (W/nf + 0.18u)' nrd='0.18u / W' nrs='0.18u / W' sa=0 sb=0 sd=0 m=24 par=24
XM10 outb1p vbn1 vss vss nfet_03v3 L=1u W=1u nf=1 ad='int((nf+1)/2) * W/nf * 0.18u' as='int((nf+2)/2) * W/nf * 0.18u' pd='2*int((nf+1)/2) * (W/nf + 0.18u)'
+ ps='2*int((nf+2)/2) * (W/nf + 0.18u)' nrd='0.18u / W' nrs='0.18u / W' sa=0 sb=0 sd=0 m=24 par=24
XM8 mirr vbn2 outb1n vss nfet_03v3 L=4u W=2u nf=1 ad='int((nf+1)/2) * W/nf * 0.18u' as='int((nf+2)/2) * W/nf * 0.18u' pd='2*int((nf+1)/2) * (W/nf + 0.18u)'
+ ps='2*int((nf+2)/2) * (W/nf + 0.18u)' nrd='0.18u / W' nrs='0.18u / W' sa=0 sb=0 sd=0 m=16 par=16
XM9 outs1 vbn2 outb1p vss nfet_03v3 L=4u W=2u nf=1 ad='int((nf+1)/2) * W/nf * 0.18u' as='int((nf+2)/2) * W/nf * 0.18u' pd='2*int((nf+1)/2) * (W/nf + 0.18u)'
+ ps='2*int((nf+2)/2) * (W/nf + 0.18u)' nrd='0.18u / W' nrs='0.18u / W' sa=0 sb=0 sd=0 m=16 par=16
XM11 out outs1 net1 vss nfet_03v3 L=4u W=4u nf=1 ad='int((nf+1)/2) * W/nf * 0.18u' as='int((nf+2)/2) * W/nf * 0.18u' pd='2*int((nf+1)/2) * (W/nf + 0.18u)'
+ ps='2*int((nf+2)/2) * (W/nf + 0.18u)' nrd='0.18u / W' nrs='0.18u / W' sa=0 sb=0 sd=0 m=4 par=4
XM23 vss vbn2 vss vss nfet_03v3 L=4u W=2u nf=1 ad='int((nf+1)/2) * W/nf * 0.18u' as='int((nf+2)/2) * W/nf * 0.18u' pd='2*int((nf+1)/2) * (W/nf + 0.18u)'
+ ps='2*int((nf+2)/2) * (W/nf + 0.18u)' nrd='0.18u / W' nrs='0.18u / W' sa=0 sb=0 sd=0 m=4 par=4
XM24 vss vss vss vss nfet_03v3 L=1u W=1u nf=1 ad='int((nf+1)/2) * W/nf * 0.18u' as='int((nf+2)/2) * W/nf * 0.18u' pd='2*int((nf+1)/2) * (W/nf + 0.18u)'
+ ps='2*int((nf+2)/2) * (W/nf + 0.18u)' nrd='0.18u / W' nrs='0.18u / W' sa=0 sb=0 sd=0 m=12 par=12
XM25 bias ena vdd vdd pfet_03v3 L=0.28u W=1.0u nf=1 ad='int((nf+1)/2) * W/nf * 0.18u' as='int((nf+2)/2) * W/nf * 0.18u' pd='2*int((nf+1)/2) * (W/nf + 0.18u)'
+ ps='2*int((nf+2)/2) * (W/nf + 0.18u)' nrd='0.18u / W' nrs='0.18u / W' sa=0 sb=0 sd=0 m=1 par=1
XM26 outs1 ena vdd vdd pfet_03v3 L=0.28u W=1.0u nf=1 ad='int((nf+1)/2) * W/nf * 0.18u' as='int((nf+2)/2) * W/nf * 0.18u' pd='2*int((nf+1)/2) * (W/nf + 0.18u)'
+ ps='2*int((nf+2)/2) * (W/nf + 0.18u)' nrd='0.18u / W' nrs='0.18u / W' sa=0 sb=0 sd=0 m=1 par=1
XM27 net1 ena vss vss nfet_03v3 L=0.28u W=4u nf=1 ad='int((nf+1)/2) * W/nf * 0.18u' as='int((nf+2)/2) * W/nf * 0.18u' pd='2*int((nf+1)/2) * (W/nf + 0.18u)'
+ ps='2*int((nf+2)/2) * (W/nf + 0.18u)' nrd='0.18u / W' nrs='0.18u / W' sa=0 sb=0 sd=0 m=8 par=8
XM2 vdd vdd vdd vdd pfet_03v3 L=4.0u W=1.0u nf=1 ad='int((nf+1)/2) * W/nf * 0.18u' as='int((nf+2)/2) * W/nf * 0.18u' pd='2*int((nf+1)/2) * (W/nf + 0.18u)'
+ ps='2*int((nf+2)/2) * (W/nf + 0.18u)' nrd='0.18u / W' nrs='0.18u / W' sa=0 sb=0 sd=0 m=4 par=4
XM28 vss vss vss vss nfet_03v3 L=4u W=2u nf=1 ad='int((nf+1)/2) * W/nf * 0.18u' as='int((nf+2)/2) * W/nf * 0.18u' pd='2*int((nf+1)/2) * (W/nf + 0.18u)'
+ ps='2*int((nf+2)/2) * (W/nf + 0.18u)' nrd='0.18u / W' nrs='0.18u / W' sa=0 sb=0 sd=0 m=4 par=4
XM29 vdd vdd vdd vdd pfet_03v3 L=0.5u W=1.0u nf=1 ad='int((nf+1)/2) * W/nf * 0.18u' as='int((nf+2)/2) * W/nf * 0.18u' pd='2*int((nf+1)/2) * (W/nf + 0.18u)'
+ ps='2*int((nf+2)/2) * (W/nf + 0.18u)' nrd='0.18u / W' nrs='0.18u / W' sa=0 sb=0 sd=0 m=12 par=12
.ends

* expanding   symbol:  bias_nset.sym # of pins=7
** sym_path: /home/tim/gits/gf180mcu_ocd_chipalooza/dependencies/gf180mcu_ocd_ip__biasgen/xschem/bias_nset.sym
** sch_path: /home/tim/gits/gf180mcu_ocd_chipalooza/dependencies/gf180mcu_ocd_ip__biasgen/xschem/bias_nset.sch
.subckt bias_nset itail ena ncasc nbias avss shld2 shld3
*.PININFO avss:B ena:I itail:B nbias:O ncasc:O shld2:B shld3:B
XM1 nbias nbias avss avss nfet_05v0 L=1.0u W=3.0u nf=1 ad='int((nf+1)/2) * W/nf * 0.18u' as='int((nf+2)/2) * W/nf * 0.18u' pd='2*int((nf+1)/2) * (W/nf + 0.18u)'
+ ps='2*int((nf+2)/2) * (W/nf + 0.18u)' nrd='0.18u / W' nrs='0.18u / W' sa=0 sb=0 sd=0 m=1 par=1
XM2 ncasc ncasc nbias avss nfet_05v0 L=1.0u W=3.0u nf=1 ad='int((nf+1)/2) * W/nf * 0.18u' as='int((nf+2)/2) * W/nf * 0.18u' pd='2*int((nf+1)/2) * (W/nf + 0.18u)'
+ ps='2*int((nf+2)/2) * (W/nf + 0.18u)' nrd='0.18u / W' nrs='0.18u / W' sa=0 sb=0 sd=0 m=1 par=1
XM3 itail ena ncasc avss nfet_05v0 L=1.0u W=3.0u nf=1 ad='int((nf+1)/2) * W/nf * 0.18u' as='int((nf+2)/2) * W/nf * 0.18u' pd='2*int((nf+1)/2) * (W/nf + 0.18u)'
+ ps='2*int((nf+2)/2) * (W/nf + 0.18u)' nrd='0.18u / W' nrs='0.18u / W' sa=0 sb=0 sd=0 m=1 par=1
.ends

* expanding   symbol:  bias_pset.sym # of pins=6
** sym_path: /home/tim/gits/gf180mcu_ocd_chipalooza/dependencies/gf180mcu_ocd_ip__biasgen/xschem/bias_pset.sym
** sch_path: /home/tim/gits/gf180mcu_ocd_chipalooza/dependencies/gf180mcu_ocd_ip__biasgen/xschem/bias_pset.sch
.subckt bias_pset avdd pbias pcasc enb itail shld3
*.PININFO pbias:B itail:B enb:I pcasc:O avdd:B shld3:B
XM1 pbias pbias avdd avdd pfet_05v0 L=1.0u W=3.0u nf=1 ad='int((nf+1)/2) * W/nf * 0.18u' as='int((nf+2)/2) * W/nf * 0.18u' pd='2*int((nf+1)/2) * (W/nf + 0.18u)'
+ ps='2*int((nf+2)/2) * (W/nf + 0.18u)' nrd='0.18u / W' nrs='0.18u / W' sa=0 sb=0 sd=0 m=1 par=1
XM2 pcasc pcasc pbias avdd pfet_05v0 L=1.0u W=3.0u nf=1 ad='int((nf+1)/2) * W/nf * 0.18u' as='int((nf+2)/2) * W/nf * 0.18u' pd='2*int((nf+1)/2) * (W/nf + 0.18u)'
+ ps='2*int((nf+2)/2) * (W/nf + 0.18u)' nrd='0.18u / W' nrs='0.18u / W' sa=0 sb=0 sd=0 m=1 par=1
XM3 itail enb pcasc avdd pfet_05v0 L=1.0u W=3.0u nf=1 ad='int((nf+1)/2) * W/nf * 0.18u' as='int((nf+2)/2) * W/nf * 0.18u' pd='2*int((nf+1)/2) * (W/nf + 0.18u)'
+ ps='2*int((nf+2)/2) * (W/nf + 0.18u)' nrd='0.18u / W' nrs='0.18u / W' sa=0 sb=0 sd=0 m=1 par=1
.ends

* expanding   symbol:  bias_amp_large.sym # of pins=7
** sym_path: /home/tim/gits/gf180mcu_ocd_chipalooza/dependencies/gf180mcu_ocd_ip__biasgen/xschem/bias_amp_large.sym
** sch_path: /home/tim/gits/gf180mcu_ocd_chipalooza/dependencies/gf180mcu_ocd_ip__biasgen/xschem/bias_amp_large.sch
.subckt bias_amp_large avdd out inn inp nbias avss ena
*.PININFO inp:I nbias:I inn:I out:O avdd:B avss:B ena:I
XM8 out outn avdd avdd pfet_05v0 L=0.50u W=10.0u nf=10 ad='int((nf+1)/2) * W/nf * 0.18u' as='int((nf+2)/2) * W/nf * 0.18u' pd='2*int((nf+1)/2) * (W/nf + 0.18u)'
+ ps='2*int((nf+2)/2) * (W/nf + 0.18u)' nrd='0.18u / W' nrs='0.18u / W' sa=0 sb=0 sd=0 m=1 par=1
XM9 net1 nbias avss avss nfet_05v0 L=0.60u W=20.0u nf=20 ad='int((nf+1)/2) * W/nf * 0.18u' as='int((nf+2)/2) * W/nf * 0.18u' pd='2*int((nf+1)/2) * (W/nf + 0.18u)'
+ ps='2*int((nf+2)/2) * (W/nf + 0.18u)' nrd='0.18u / W' nrs='0.18u / W' sa=0 sb=0 sd=0 m=1 par=1
XM1 vcom ena net1 avss nfet_05v0 L=0.60u W=20.0u nf=20 ad='int((nf+1)/2) * W/nf * 0.18u' as='int((nf+2)/2) * W/nf * 0.18u' pd='2*int((nf+1)/2) * (W/nf + 0.18u)'
+ ps='2*int((nf+2)/2) * (W/nf + 0.18u)' nrd='0.18u / W' nrs='0.18u / W' sa=0 sb=0 sd=0 m=1 par=1
XM4 outn inp vcom avss nfet_05v0 L=0.60u W=20.0u nf=20 ad='int((nf+1)/2) * W/nf * 0.18u' as='int((nf+2)/2) * W/nf * 0.18u' pd='2*int((nf+1)/2) * (W/nf + 0.18u)'
+ ps='2*int((nf+2)/2) * (W/nf + 0.18u)' nrd='0.18u / W' nrs='0.18u / W' sa=0 sb=0 sd=0 m=1 par=1
XM5 out inn vcom avss nfet_05v0 L=0.60u W=20.0u nf=20 ad='int((nf+1)/2) * W/nf * 0.18u' as='int((nf+2)/2) * W/nf * 0.18u' pd='2*int((nf+1)/2) * (W/nf + 0.18u)'
+ ps='2*int((nf+2)/2) * (W/nf + 0.18u)' nrd='0.18u / W' nrs='0.18u / W' sa=0 sb=0 sd=0 m=1 par=1
XM2 outn outn avdd avdd pfet_05v0 L=0.50u W=10.0u nf=10 ad='int((nf+1)/2) * W/nf * 0.18u' as='int((nf+2)/2) * W/nf * 0.18u' pd='2*int((nf+1)/2) * (W/nf + 0.18u)'
+ ps='2*int((nf+2)/2) * (W/nf + 0.18u)' nrd='0.18u / W' nrs='0.18u / W' sa=0 sb=0 sd=0 m=1 par=1
XM3 avdd avdd avdd avdd pfet_05v0 L=0.50u W=4.0u nf=4 ad='int((nf+1)/2) * W/nf * 0.18u' as='int((nf+2)/2) * W/nf * 0.18u' pd='2*int((nf+1)/2) * (W/nf + 0.18u)'
+ ps='2*int((nf+2)/2) * (W/nf + 0.18u)' nrd='0.18u / W' nrs='0.18u / W' sa=0 sb=0 sd=0 m=1 par=1
XM6 avss nbias avss avss nfet_05v0 L=0.60u W=6.0u nf=6 ad='int((nf+1)/2) * W/nf * 0.18u' as='int((nf+2)/2) * W/nf * 0.18u' pd='2*int((nf+1)/2) * (W/nf + 0.18u)'
+ ps='2*int((nf+2)/2) * (W/nf + 0.18u)' nrd='0.18u / W' nrs='0.18u / W' sa=0 sb=0 sd=0 m=1 par=1
.ends

* expanding   symbol:  bias_pset2.sym # of pins=7
** sym_path: /home/tim/gits/gf180mcu_ocd_chipalooza/dependencies/gf180mcu_ocd_ip__biasgen/xschem/bias_pset2.sym
** sch_path: /home/tim/gits/gf180mcu_ocd_chipalooza/dependencies/gf180mcu_ocd_ip__biasgen/xschem/bias_pset2.sch
.subckt bias_pset2 avdd pbias pcasc enb itail shld2 shld3
*.PININFO pbias:B itail:B enb:I pcasc:O avdd:B shld2:B shld3:B
XM1 pbias pbias avdd avdd pfet_05v0 L=1.0u W=3.0u nf=1 ad='int((nf+1)/2) * W/nf * 0.18u' as='int((nf+2)/2) * W/nf * 0.18u' pd='2*int((nf+1)/2) * (W/nf + 0.18u)'
+ ps='2*int((nf+2)/2) * (W/nf + 0.18u)' nrd='0.18u / W' nrs='0.18u / W' sa=0 sb=0 sd=0 m=1 par=1
XM2 pcasc pcasc pbias avdd pfet_05v0 L=1.0u W=3.0u nf=1 ad='int((nf+1)/2) * W/nf * 0.18u' as='int((nf+2)/2) * W/nf * 0.18u' pd='2*int((nf+1)/2) * (W/nf + 0.18u)'
+ ps='2*int((nf+2)/2) * (W/nf + 0.18u)' nrd='0.18u / W' nrs='0.18u / W' sa=0 sb=0 sd=0 m=1 par=1
XM3 itail enb pcasc avdd pfet_05v0 L=1.0u W=3.0u nf=1 ad='int((nf+1)/2) * W/nf * 0.18u' as='int((nf+2)/2) * W/nf * 0.18u' pd='2*int((nf+1)/2) * (W/nf + 0.18u)'
+ ps='2*int((nf+2)/2) * (W/nf + 0.18u)' nrd='0.18u / W' nrs='0.18u / W' sa=0 sb=0 sd=0 m=1 par=1
.ends

* expanding   symbol:  bg_res.sym # of pins=11
** sym_path: /home/tim/gits/gf180mcu_ocd_chipalooza/dependencies/gf180mcu_ocd_ip__biasgen/xschem/bg_res.sym
** sch_path: /home/tim/gits/gf180mcu_ocd_chipalooza/dependencies/gf180mcu_ocd_ip__biasgen/xschem/bg_res.sch
.subckt bg_res b a d c vss f h k e g j
*.PININFO a:I b:I c:O d:O vss:B f:O e:I h:O g:I k:O j:I
XR28 f e vss ppolyf_u r_width=1.0e-6 r_length=15.00e-6 m=1
XR12 h g vss ppolyf_u r_width=1.0e-6 r_length=15.00e-6 m=1
XR1 net3 b vss ppolyf_u r_width=1.0e-6 r_length=15.00e-6 m=1
XR2 net4 a vss ppolyf_u r_width=1.0e-6 r_length=15.00e-6 m=1
XR3 net2 net3 vss ppolyf_u r_width=1.0e-6 r_length=15.00e-6 m=1
XR4 net1 net4 vss ppolyf_u r_width=1.0e-6 r_length=15.00e-6 m=1
XR5 net7 net2 vss ppolyf_u r_width=1.0e-6 r_length=15.00e-6 m=1
XR6 net8 net1 vss ppolyf_u r_width=1.0e-6 r_length=15.00e-6 m=1
XR7 net6 net7 vss ppolyf_u r_width=1.0e-6 r_length=15.00e-6 m=1
XR8 net5 net8 vss ppolyf_u r_width=1.0e-6 r_length=15.00e-6 m=1
XR9 net11 net6 vss ppolyf_u r_width=1.0e-6 r_length=15.00e-6 m=1
XR10 net12 net5 vss ppolyf_u r_width=1.0e-6 r_length=15.00e-6 m=1
XR11 net10 net11 vss ppolyf_u r_width=1.0e-6 r_length=15.00e-6 m=1
XR13 net9 net12 vss ppolyf_u r_width=1.0e-6 r_length=15.00e-6 m=1
XR14 net13 net10 vss ppolyf_u r_width=1.0e-6 r_length=15.00e-6 m=1
XR15 net14 net9 vss ppolyf_u r_width=1.0e-6 r_length=15.00e-6 m=1
XR16 net15 net13 vss ppolyf_u r_width=1.0e-6 r_length=15.00e-6 m=1
XR17 net16 net14 vss ppolyf_u r_width=1.0e-6 r_length=15.00e-6 m=1
XR18 net17 net15 vss ppolyf_u r_width=1.0e-6 r_length=15.00e-6 m=1
XR19 net18 net16 vss ppolyf_u r_width=1.0e-6 r_length=15.00e-6 m=1
XR20 net19 net17 vss ppolyf_u r_width=1.0e-6 r_length=15.00e-6 m=1
XR21 net20 net18 vss ppolyf_u r_width=1.0e-6 r_length=15.00e-6 m=1
XR22 net21 net19 vss ppolyf_u r_width=1.0e-6 r_length=15.00e-6 m=1
XR23 net22 net20 vss ppolyf_u r_width=1.0e-6 r_length=15.00e-6 m=1
XR24 d net21 vss ppolyf_u r_width=1.0e-6 r_length=15.00e-6 m=1
XR25 c net22 vss ppolyf_u r_width=1.0e-6 r_length=15.00e-6 m=1
XR26 k j vss ppolyf_u r_width=1.0e-6 r_length=15.00e-6 m=1
.ends

* expanding   symbol:  bg_trim.sym # of pins=4
** sym_path: /home/tim/gits/gf180mcu_ocd_chipalooza/dependencies/gf180mcu_ocd_ip__biasgen/xschem/bg_trim.sym
** sch_path: /home/tim/gits/gf180mcu_ocd_chipalooza/dependencies/gf180mcu_ocd_ip__biasgen/xschem/bg_trim.sch
.subckt bg_trim top bot ctrl[15] ctrl[14] ctrl[13] ctrl[12] ctrl[11] ctrl[10] ctrl[9] ctrl[8] ctrl[7] ctrl[6] ctrl[5] ctrl[4]
+ ctrl[3] ctrl[2] ctrl[1] ctrl[0] vss
*.PININFO vss:B ctrl[15:0]:I bot:B top:B
XM1 top ctrl[15] bot vss nfet_03v3 L=0.28u W=3.1u nf=1 ad='int((nf+1)/2) * W/nf * 0.18u' as='int((nf+2)/2) * W/nf * 0.18u' pd='2*int((nf+1)/2) * (W/nf + 0.18u)'
+ ps='2*int((nf+2)/2) * (W/nf + 0.18u)' nrd='0.18u / W' nrs='0.18u / W' sa=0 sb=0 sd=0 m=1 par=1
XR19 net12 top vss ppolyf_u r_width=1e-6 r_length=2.63e-6 m=6
XM17 bot bot bot vss nfet_03v3 L=0.28u W=3.1u nf=1 ad='int((nf+1)/2) * W/nf * 0.18u' as='int((nf+2)/2) * W/nf * 0.18u' pd='2*int((nf+1)/2) * (W/nf + 0.18u)'
+ ps='2*int((nf+2)/2) * (W/nf + 0.18u)' nrd='0.18u / W' nrs='0.18u / W' sa=0 sb=0 sd=0 m=1 par=1
XM2 net12 ctrl[14] bot vss nfet_03v3 L=0.28u W=3.1u nf=1 ad='int((nf+1)/2) * W/nf * 0.18u' as='int((nf+2)/2) * W/nf * 0.18u' pd='2*int((nf+1)/2) * (W/nf + 0.18u)'
+ ps='2*int((nf+2)/2) * (W/nf + 0.18u)' nrd='0.18u / W' nrs='0.18u / W' sa=0 sb=0 sd=0 m=1 par=1
XM3 net11 ctrl[13] bot vss nfet_03v3 L=0.28u W=3.1u nf=1 ad='int((nf+1)/2) * W/nf * 0.18u' as='int((nf+2)/2) * W/nf * 0.18u' pd='2*int((nf+1)/2) * (W/nf + 0.18u)'
+ ps='2*int((nf+2)/2) * (W/nf + 0.18u)' nrd='0.18u / W' nrs='0.18u / W' sa=0 sb=0 sd=0 m=1 par=1
XR1 net11 net12 vss ppolyf_u r_width=1e-6 r_length=2.63e-6 m=6
XR2 net9 net11 vss ppolyf_u r_width=1e-6 r_length=2.63e-6 m=6
XR3 net10 net9 vss ppolyf_u r_width=1e-6 r_length=2.63e-6 m=6
XR4 net15 net10 vss ppolyf_u r_width=1e-6 r_length=2.63e-6 m=6
XR5 net14 net15 vss ppolyf_u r_width=1e-6 r_length=2.63e-6 m=6
XR6 net13 net14 vss ppolyf_u r_width=1e-6 r_length=2.63e-6 m=6
XR7 net8 net13 vss ppolyf_u r_width=1e-6 r_length=2.63e-6 m=6
XR8 net7 net8 vss ppolyf_u r_width=1e-6 r_length=2.63e-6 m=6
XR9 net6 net7 vss ppolyf_u r_width=1e-6 r_length=2.63e-6 m=6
XR10 net5 net6 vss ppolyf_u r_width=1e-6 r_length=2.63e-6 m=6
XR11 net4 net5 vss ppolyf_u r_width=1e-6 r_length=2.63e-6 m=6
XR12 net3 net4 vss ppolyf_u r_width=1e-6 r_length=2.63e-6 m=6
XR13 net2 net3 vss ppolyf_u r_width=1e-6 r_length=2.63e-6 m=6
XR14 net1 net2 vss ppolyf_u r_width=1e-6 r_length=2.63e-6 m=6
XR15 bot net1 vss ppolyf_u r_width=1e-6 r_length=2.63e-6 m=6
XR16 vss vss vss ppolyf_u r_width=1e-6 r_length=2.63e-6 m=6
XR17 top top vss ppolyf_u r_width=1e-6 r_length=2.63e-6 m=6
XM4 net9 ctrl[12] bot vss nfet_03v3 L=0.28u W=3.1u nf=1 ad='int((nf+1)/2) * W/nf * 0.18u' as='int((nf+2)/2) * W/nf * 0.18u' pd='2*int((nf+1)/2) * (W/nf + 0.18u)'
+ ps='2*int((nf+2)/2) * (W/nf + 0.18u)' nrd='0.18u / W' nrs='0.18u / W' sa=0 sb=0 sd=0 m=1 par=1
XM5 net10 ctrl[11] bot vss nfet_03v3 L=0.28u W=3.1u nf=1 ad='int((nf+1)/2) * W/nf * 0.18u' as='int((nf+2)/2) * W/nf * 0.18u' pd='2*int((nf+1)/2) * (W/nf + 0.18u)'
+ ps='2*int((nf+2)/2) * (W/nf + 0.18u)' nrd='0.18u / W' nrs='0.18u / W' sa=0 sb=0 sd=0 m=1 par=1
XM6 net15 ctrl[10] bot vss nfet_03v3 L=0.28u W=3.1u nf=1 ad='int((nf+1)/2) * W/nf * 0.18u' as='int((nf+2)/2) * W/nf * 0.18u' pd='2*int((nf+1)/2) * (W/nf + 0.18u)'
+ ps='2*int((nf+2)/2) * (W/nf + 0.18u)' nrd='0.18u / W' nrs='0.18u / W' sa=0 sb=0 sd=0 m=1 par=1
XM7 net14 ctrl[9] bot vss nfet_03v3 L=0.28u W=3.1u nf=1 ad='int((nf+1)/2) * W/nf * 0.18u' as='int((nf+2)/2) * W/nf * 0.18u' pd='2*int((nf+1)/2) * (W/nf + 0.18u)'
+ ps='2*int((nf+2)/2) * (W/nf + 0.18u)' nrd='0.18u / W' nrs='0.18u / W' sa=0 sb=0 sd=0 m=1 par=1
XM8 net13 ctrl[8] bot vss nfet_03v3 L=0.28u W=3.1u nf=1 ad='int((nf+1)/2) * W/nf * 0.18u' as='int((nf+2)/2) * W/nf * 0.18u' pd='2*int((nf+1)/2) * (W/nf + 0.18u)'
+ ps='2*int((nf+2)/2) * (W/nf + 0.18u)' nrd='0.18u / W' nrs='0.18u / W' sa=0 sb=0 sd=0 m=1 par=1
XM9 net8 ctrl[7] bot vss nfet_03v3 L=0.28u W=3.1u nf=1 ad='int((nf+1)/2) * W/nf * 0.18u' as='int((nf+2)/2) * W/nf * 0.18u' pd='2*int((nf+1)/2) * (W/nf + 0.18u)'
+ ps='2*int((nf+2)/2) * (W/nf + 0.18u)' nrd='0.18u / W' nrs='0.18u / W' sa=0 sb=0 sd=0 m=1 par=1
XM10 net7 ctrl[6] bot vss nfet_03v3 L=0.28u W=3.1u nf=1 ad='int((nf+1)/2) * W/nf * 0.18u' as='int((nf+2)/2) * W/nf * 0.18u' pd='2*int((nf+1)/2) * (W/nf + 0.18u)'
+ ps='2*int((nf+2)/2) * (W/nf + 0.18u)' nrd='0.18u / W' nrs='0.18u / W' sa=0 sb=0 sd=0 m=1 par=1
XM11 net6 ctrl[5] bot vss nfet_03v3 L=0.28u W=3.1u nf=1 ad='int((nf+1)/2) * W/nf * 0.18u' as='int((nf+2)/2) * W/nf * 0.18u' pd='2*int((nf+1)/2) * (W/nf + 0.18u)'
+ ps='2*int((nf+2)/2) * (W/nf + 0.18u)' nrd='0.18u / W' nrs='0.18u / W' sa=0 sb=0 sd=0 m=1 par=1
XM12 net5 ctrl[4] bot vss nfet_03v3 L=0.28u W=3.1u nf=1 ad='int((nf+1)/2) * W/nf * 0.18u' as='int((nf+2)/2) * W/nf * 0.18u' pd='2*int((nf+1)/2) * (W/nf + 0.18u)'
+ ps='2*int((nf+2)/2) * (W/nf + 0.18u)' nrd='0.18u / W' nrs='0.18u / W' sa=0 sb=0 sd=0 m=1 par=1
XM13 net4 ctrl[3] bot vss nfet_03v3 L=0.28u W=3.1u nf=1 ad='int((nf+1)/2) * W/nf * 0.18u' as='int((nf+2)/2) * W/nf * 0.18u' pd='2*int((nf+1)/2) * (W/nf + 0.18u)'
+ ps='2*int((nf+2)/2) * (W/nf + 0.18u)' nrd='0.18u / W' nrs='0.18u / W' sa=0 sb=0 sd=0 m=1 par=1
XM14 net3 ctrl[2] bot vss nfet_03v3 L=0.28u W=3.1u nf=1 ad='int((nf+1)/2) * W/nf * 0.18u' as='int((nf+2)/2) * W/nf * 0.18u' pd='2*int((nf+1)/2) * (W/nf + 0.18u)'
+ ps='2*int((nf+2)/2) * (W/nf + 0.18u)' nrd='0.18u / W' nrs='0.18u / W' sa=0 sb=0 sd=0 m=1 par=1
XM15 net2 ctrl[1] bot vss nfet_03v3 L=0.28u W=3.1u nf=1 ad='int((nf+1)/2) * W/nf * 0.18u' as='int((nf+2)/2) * W/nf * 0.18u' pd='2*int((nf+1)/2) * (W/nf + 0.18u)'
+ ps='2*int((nf+2)/2) * (W/nf + 0.18u)' nrd='0.18u / W' nrs='0.18u / W' sa=0 sb=0 sd=0 m=1 par=1
XM16 net1 ctrl[0] bot vss nfet_03v3 L=0.28u W=3.1u nf=1 ad='int((nf+1)/2) * W/nf * 0.18u' as='int((nf+2)/2) * W/nf * 0.18u' pd='2*int((nf+1)/2) * (W/nf + 0.18u)'
+ ps='2*int((nf+2)/2) * (W/nf + 0.18u)' nrd='0.18u / W' nrs='0.18u / W' sa=0 sb=0 sd=0 m=1 par=1
.ends

* expanding   symbol:  se_folded_cascode_p.sym # of pins=7
** sym_path: /home/tim/gits/gf180mcu_ocd_chipalooza/dependencies/gf180mcu_ocd_ip__biasgen/xschem/se_folded_cascode_p.sym
** sch_path: /home/tim/gits/gf180mcu_ocd_chipalooza/dependencies/gf180mcu_ocd_ip__biasgen/xschem/se_folded_cascode_p.sch
.subckt se_folded_cascode_p vdd out inp inn vss bias ena
*.PININFO inn:I inp:I out:O bias:B vdd:B vss:B ena:I
XM14 vbp1 vbp1 vdd vdd pfet_03v3 L=1u W=1u nf=1 ad='int((nf+1)/2) * W/nf * 0.18u' as='int((nf+2)/2) * W/nf * 0.18u' pd='2*int((nf+1)/2) * (W/nf + 0.18u)'
+ ps='2*int((nf+2)/2) * (W/nf + 0.18u)' nrd='0.18u / W' nrs='0.18u / W' sa=0 sb=0 sd=0 m=4 par=4
XM15 bias bias vbp1 vdd pfet_03v3 L=0.5u W=2u nf=1 ad='int((nf+1)/2) * W/nf * 0.18u' as='int((nf+2)/2) * W/nf * 0.18u' pd='2*int((nf+1)/2) * (W/nf + 0.18u)'
+ ps='2*int((nf+2)/2) * (W/nf + 0.18u)' nrd='0.18u / W' nrs='0.18u / W' sa=0 sb=0 sd=0 m=8 par=8
XM17 vbn2 vbp1 vdd vdd pfet_03v3 L=1u W=1u nf=1 ad='int((nf+1)/2) * W/nf * 0.18u' as='int((nf+2)/2) * W/nf * 0.18u' pd='2*int((nf+1)/2) * (W/nf + 0.18u)'
+ ps='2*int((nf+2)/2) * (W/nf + 0.18u)' nrd='0.18u / W' nrs='0.18u / W' sa=0 sb=0 sd=0 m=4 par=4
XM18 vbn2 vbn2 vbn1 vss nfet_03v3 L=4u W=1u nf=1 ad='int((nf+1)/2) * W/nf * 0.18u' as='int((nf+2)/2) * W/nf * 0.18u' pd='2*int((nf+1)/2) * (W/nf + 0.18u)'
+ ps='2*int((nf+2)/2) * (W/nf + 0.18u)' nrd='0.18u / W' nrs='0.18u / W' sa=0 sb=0 sd=0 m=4 par=4
XM19 vbn1 vbn1 vss vss nfet_03v3 L=1u W=1u nf=1 ad='int((nf+1)/2) * W/nf * 0.18u' as='int((nf+2)/2) * W/nf * 0.18u' pd='2*int((nf+1)/2) * (W/nf + 0.18u)'
+ ps='2*int((nf+2)/2) * (W/nf + 0.18u)' nrd='0.18u / W' nrs='0.18u / W' sa=0 sb=0 sd=0 m=4 par=4
XM20 diff vbp1 vdd vdd pfet_03v3 L=1u W=1u nf=1 ad='int((nf+1)/2) * W/nf * 0.18u' as='int((nf+2)/2) * W/nf * 0.18u' pd='2*int((nf+1)/2) * (W/nf + 0.18u)'
+ ps='2*int((nf+2)/2) * (W/nf + 0.18u)' nrd='0.18u / W' nrs='0.18u / W' sa=0 sb=0 sd=0 m=16 par=16
XM1 out1n inp diff vdd pfet_03v3 L=1u W=4u nf=1 ad='int((nf+1)/2) * W/nf * 0.18u' as='int((nf+2)/2) * W/nf * 0.18u' pd='2*int((nf+1)/2) * (W/nf + 0.18u)'
+ ps='2*int((nf+2)/2) * (W/nf + 0.18u)' nrd='0.18u / W' nrs='0.18u / W' sa=0 sb=0 sd=0 m=8 par=8
XM2 out1p inn diff vdd pfet_03v3 L=1u W=4u nf=1 ad='int((nf+1)/2) * W/nf * 0.18u' as='int((nf+2)/2) * W/nf * 0.18u' pd='2*int((nf+1)/2) * (W/nf + 0.18u)'
+ ps='2*int((nf+2)/2) * (W/nf + 0.18u)' nrd='0.18u / W' nrs='0.18u / W' sa=0 sb=0 sd=0 m=8 par=8
XM3 nd10 mirr vdd vdd pfet_03v3 L=4u W=2u nf=1 ad='int((nf+1)/2) * W/nf * 0.18u' as='int((nf+2)/2) * W/nf * 0.18u' pd='2*int((nf+1)/2) * (W/nf + 0.18u)'
+ ps='2*int((nf+2)/2) * (W/nf + 0.18u)' nrd='0.18u / W' nrs='0.18u / W' sa=0 sb=0 sd=0 m=8 par=8
XM8 nd11 mirr vdd vdd pfet_03v3 L=4u W=2u nf=1 ad='int((nf+1)/2) * W/nf * 0.18u' as='int((nf+2)/2) * W/nf * 0.18u' pd='2*int((nf+1)/2) * (W/nf + 0.18u)'
+ ps='2*int((nf+2)/2) * (W/nf + 0.18u)' nrd='0.18u / W' nrs='0.18u / W' sa=0 sb=0 sd=0 m=8 par=8
XM9 out bias nd11 vdd pfet_03v3 L=0.5u W=2u nf=1 ad='int((nf+1)/2) * W/nf * 0.18u' as='int((nf+2)/2) * W/nf * 0.18u' pd='2*int((nf+1)/2) * (W/nf + 0.18u)'
+ ps='2*int((nf+2)/2) * (W/nf + 0.18u)' nrd='0.18u / W' nrs='0.18u / W' sa=0 sb=0 sd=0 m=16 par=16
XM10 mirr bias nd10 vdd pfet_03v3 L=0.5u W=2u nf=1 ad='int((nf+1)/2) * W/nf * 0.18u' as='int((nf+2)/2) * W/nf * 0.18u' pd='2*int((nf+1)/2) * (W/nf + 0.18u)'
+ ps='2*int((nf+2)/2) * (W/nf + 0.18u)' nrd='0.18u / W' nrs='0.18u / W' sa=0 sb=0 sd=0 m=16 par=16
XM4 out vbn2 out1p vss nfet_03v3 L=4u W=1u nf=1 ad='int((nf+1)/2) * W/nf * 0.18u' as='int((nf+2)/2) * W/nf * 0.18u' pd='2*int((nf+1)/2) * (W/nf + 0.18u)'
+ ps='2*int((nf+2)/2) * (W/nf + 0.18u)' nrd='0.18u / W' nrs='0.18u / W' sa=0 sb=0 sd=0 m=8 par=8
XM5 out1p vbn1 vss vss nfet_03v3 L=1u W=1u nf=1 ad='int((nf+1)/2) * W/nf * 0.18u' as='int((nf+2)/2) * W/nf * 0.18u' pd='2*int((nf+1)/2) * (W/nf + 0.18u)'
+ ps='2*int((nf+2)/2) * (W/nf + 0.18u)' nrd='0.18u / W' nrs='0.18u / W' sa=0 sb=0 sd=0 m=16 par=16
XM6 out1n vbn1 vss vss nfet_03v3 L=1u W=1u nf=1 ad='int((nf+1)/2) * W/nf * 0.18u' as='int((nf+2)/2) * W/nf * 0.18u' pd='2*int((nf+1)/2) * (W/nf + 0.18u)'
+ ps='2*int((nf+2)/2) * (W/nf + 0.18u)' nrd='0.18u / W' nrs='0.18u / W' sa=0 sb=0 sd=0 m=16 par=16
XM7 mirr vbn2 out1n vss nfet_03v3 L=4u W=1u nf=1 ad='int((nf+1)/2) * W/nf * 0.18u' as='int((nf+2)/2) * W/nf * 0.18u' pd='2*int((nf+1)/2) * (W/nf + 0.18u)'
+ ps='2*int((nf+2)/2) * (W/nf + 0.18u)' nrd='0.18u / W' nrs='0.18u / W' sa=0 sb=0 sd=0 m=8 par=8
XM11 vdd vdd vdd vdd pfet_03v3 L=1u W=4u nf=1 ad='int((nf+1)/2) * W/nf * 0.18u' as='int((nf+2)/2) * W/nf * 0.18u' pd='2*int((nf+1)/2) * (W/nf + 0.18u)'
+ ps='2*int((nf+2)/2) * (W/nf + 0.18u)' nrd='0.18u / W' nrs='0.18u / W' sa=0 sb=0 sd=0 m=8 par=8
XM12 vss vss vss vss nfet_03v3 L=1u W=1u nf=1 ad='int((nf+1)/2) * W/nf * 0.18u' as='int((nf+2)/2) * W/nf * 0.18u' pd='2*int((nf+1)/2) * (W/nf + 0.18u)'
+ ps='2*int((nf+2)/2) * (W/nf + 0.18u)' nrd='0.18u / W' nrs='0.18u / W' sa=0 sb=0 sd=0 m=14 par=14
XM13 vdd vdd vdd vdd pfet_03v3 L=4u W=2u nf=1 ad='int((nf+1)/2) * W/nf * 0.18u' as='int((nf+2)/2) * W/nf * 0.18u' pd='2*int((nf+1)/2) * (W/nf + 0.18u)'
+ ps='2*int((nf+2)/2) * (W/nf + 0.18u)' nrd='0.18u / W' nrs='0.18u / W' sa=0 sb=0 sd=0 m=4 par=4
XM21 bias ena vdd vdd pfet_03v3 L=0.5u W=1u nf=1 ad='int((nf+1)/2) * W/nf * 0.18u' as='int((nf+2)/2) * W/nf * 0.18u' pd='2*int((nf+1)/2) * (W/nf + 0.18u)'
+ ps='2*int((nf+2)/2) * (W/nf + 0.18u)' nrd='0.18u / W' nrs='0.18u / W' sa=0 sb=0 sd=0 m=1 par=1
XM16 vss vss vss vss nfet_03v3 L=2u W=1u nf=1 ad='int((nf+1)/2) * W/nf * 0.18u' as='int((nf+2)/2) * W/nf * 0.18u' pd='2*int((nf+1)/2) * (W/nf + 0.18u)'
+ ps='2*int((nf+2)/2) * (W/nf + 0.18u)' nrd='0.18u / W' nrs='0.18u / W' sa=0 sb=0 sd=0 m=2 par=2
.ends
